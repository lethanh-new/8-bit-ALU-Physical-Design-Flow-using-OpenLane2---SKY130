* NGSPICE file created from alu8bit.ext - technology: sky130A

* Black-box entry subcircuit for sky130_ef_sc_hd__decap_12 abstract view
.subckt sky130_ef_sc_hd__decap_12 VPWR VGND VPB VNB
.ends

* Black-box entry subcircuit for sky130_fd_sc_hd__fill_1 abstract view
.subckt sky130_fd_sc_hd__fill_1 VGND VNB VPB VPWR
.ends

* Black-box entry subcircuit for sky130_fd_sc_hd__nor2_1 abstract view
.subckt sky130_fd_sc_hd__nor2_1 A B VGND VNB VPB VPWR Y
.ends

* Black-box entry subcircuit for sky130_fd_sc_hd__decap_6 abstract view
.subckt sky130_fd_sc_hd__decap_6 VGND VNB VPB VPWR
.ends

* Black-box entry subcircuit for sky130_fd_sc_hd__tapvpwrvgnd_1 abstract view
.subckt sky130_fd_sc_hd__tapvpwrvgnd_1 VGND VPWR
.ends

* Black-box entry subcircuit for sky130_fd_sc_hd__fill_2 abstract view
.subckt sky130_fd_sc_hd__fill_2 VGND VNB VPB VPWR
.ends

* Black-box entry subcircuit for sky130_fd_sc_hd__decap_8 abstract view
.subckt sky130_fd_sc_hd__decap_8 VGND VNB VPB VPWR
.ends

* Black-box entry subcircuit for sky130_fd_sc_hd__nand2_1 abstract view
.subckt sky130_fd_sc_hd__nand2_1 A B VGND VNB VPB VPWR Y
.ends

* Black-box entry subcircuit for sky130_fd_sc_hd__decap_3 abstract view
.subckt sky130_fd_sc_hd__decap_3 VGND VNB VPB VPWR
.ends

* Black-box entry subcircuit for sky130_fd_sc_hd__or3_1 abstract view
.subckt sky130_fd_sc_hd__or3_1 A B C VGND VNB VPB VPWR X
.ends

* Black-box entry subcircuit for sky130_fd_sc_hd__or2_1 abstract view
.subckt sky130_fd_sc_hd__or2_1 A B VGND VNB VPB VPWR X
.ends

* Black-box entry subcircuit for sky130_fd_sc_hd__and2_1 abstract view
.subckt sky130_fd_sc_hd__and2_1 A B VGND VNB VPB VPWR X
.ends

* Black-box entry subcircuit for sky130_fd_sc_hd__a22oi_1 abstract view
.subckt sky130_fd_sc_hd__a22oi_1 A1 A2 B1 B2 VGND VNB VPB VPWR Y
.ends

* Black-box entry subcircuit for sky130_fd_sc_hd__decap_4 abstract view
.subckt sky130_fd_sc_hd__decap_4 VGND VNB VPB VPWR
.ends

* Black-box entry subcircuit for sky130_fd_sc_hd__xnor2_1 abstract view
.subckt sky130_fd_sc_hd__xnor2_1 A B VGND VNB VPB VPWR Y
.ends

* Black-box entry subcircuit for sky130_fd_sc_hd__a21oi_1 abstract view
.subckt sky130_fd_sc_hd__a21oi_1 A1 A2 B1 VGND VNB VPB VPWR Y
.ends

* Black-box entry subcircuit for sky130_fd_sc_hd__and2b_1 abstract view
.subckt sky130_fd_sc_hd__and2b_1 A_N B VGND VNB VPB VPWR X
.ends

* Black-box entry subcircuit for sky130_fd_sc_hd__and4_1 abstract view
.subckt sky130_fd_sc_hd__and4_1 A B C D VGND VNB VPB VPWR X
.ends

* Black-box entry subcircuit for sky130_fd_sc_hd__nand2b_1 abstract view
.subckt sky130_fd_sc_hd__nand2b_1 A_N B VGND VNB VPB VPWR Y
.ends

* Black-box entry subcircuit for sky130_fd_sc_hd__mux2_1 abstract view
.subckt sky130_fd_sc_hd__mux2_1 A0 A1 S VGND VNB VPB VPWR X
.ends

* Black-box entry subcircuit for sky130_fd_sc_hd__buf_2 abstract view
.subckt sky130_fd_sc_hd__buf_2 A VGND VNB VPB VPWR X
.ends

* Black-box entry subcircuit for sky130_fd_sc_hd__a21o_1 abstract view
.subckt sky130_fd_sc_hd__a21o_1 A1 A2 B1 VGND VNB VPB VPWR X
.ends

* Black-box entry subcircuit for sky130_fd_sc_hd__a21oi_4 abstract view
.subckt sky130_fd_sc_hd__a21oi_4 A1 A2 B1 VGND VNB VPB VPWR Y
.ends

* Black-box entry subcircuit for sky130_fd_sc_hd__o21ai_2 abstract view
.subckt sky130_fd_sc_hd__o21ai_2 A1 A2 B1 VGND VNB VPB VPWR Y
.ends

* Black-box entry subcircuit for sky130_fd_sc_hd__and4b_1 abstract view
.subckt sky130_fd_sc_hd__and4b_1 A_N B C D VGND VNB VPB VPWR X
.ends

* Black-box entry subcircuit for sky130_fd_sc_hd__xor2_1 abstract view
.subckt sky130_fd_sc_hd__xor2_1 A B VGND VNB VPB VPWR X
.ends

* Black-box entry subcircuit for sky130_fd_sc_hd__o31a_1 abstract view
.subckt sky130_fd_sc_hd__o31a_1 A1 A2 A3 B1 VGND VNB VPB VPWR X
.ends

* Black-box entry subcircuit for sky130_fd_sc_hd__o21ai_1 abstract view
.subckt sky130_fd_sc_hd__o21ai_1 A1 A2 B1 VGND VNB VPB VPWR Y
.ends

* Black-box entry subcircuit for sky130_fd_sc_hd__and3_1 abstract view
.subckt sky130_fd_sc_hd__and3_1 A B C VGND VNB VPB VPWR X
.ends

* Black-box entry subcircuit for sky130_fd_sc_hd__a31o_1 abstract view
.subckt sky130_fd_sc_hd__a31o_1 A1 A2 A3 B1 VGND VNB VPB VPWR X
.ends

* Black-box entry subcircuit for sky130_fd_sc_hd__o211a_1 abstract view
.subckt sky130_fd_sc_hd__o211a_1 A1 A2 B1 C1 VGND VNB VPB VPWR X
.ends

* Black-box entry subcircuit for sky130_fd_sc_hd__o2bb2a_1 abstract view
.subckt sky130_fd_sc_hd__o2bb2a_1 A1_N A2_N B1 B2 VGND VNB VPB VPWR X
.ends

* Black-box entry subcircuit for sky130_fd_sc_hd__a311oi_4 abstract view
.subckt sky130_fd_sc_hd__a311oi_4 A1 A2 A3 B1 C1 VGND VNB VPB VPWR Y
.ends

* Black-box entry subcircuit for sky130_fd_sc_hd__o21bai_1 abstract view
.subckt sky130_fd_sc_hd__o21bai_1 A1 A2 B1_N VGND VNB VPB VPWR Y
.ends

* Black-box entry subcircuit for sky130_fd_sc_hd__a211oi_2 abstract view
.subckt sky130_fd_sc_hd__a211oi_2 A1 A2 B1 C1 VGND VNB VPB VPWR Y
.ends

* Black-box entry subcircuit for sky130_fd_sc_hd__a221o_1 abstract view
.subckt sky130_fd_sc_hd__a221o_1 A1 A2 B1 B2 C1 VGND VNB VPB VPWR X
.ends

* Black-box entry subcircuit for sky130_fd_sc_hd__a32o_1 abstract view
.subckt sky130_fd_sc_hd__a32o_1 A1 A2 A3 B1 B2 VGND VNB VPB VPWR X
.ends

* Black-box entry subcircuit for sky130_fd_sc_hd__or4bb_4 abstract view
.subckt sky130_fd_sc_hd__or4bb_4 A B C_N D_N VGND VNB VPB VPWR X
.ends

* Black-box entry subcircuit for sky130_fd_sc_hd__or4_4 abstract view
.subckt sky130_fd_sc_hd__or4_4 A B C D VGND VNB VPB VPWR X
.ends

* Black-box entry subcircuit for sky130_fd_sc_hd__clkbuf_4 abstract view
.subckt sky130_fd_sc_hd__clkbuf_4 A VGND VNB VPB VPWR X
.ends

* Black-box entry subcircuit for sky130_fd_sc_hd__o22a_1 abstract view
.subckt sky130_fd_sc_hd__o22a_1 A1 A2 B1 B2 VGND VNB VPB VPWR X
.ends

* Black-box entry subcircuit for sky130_fd_sc_hd__a211o_1 abstract view
.subckt sky130_fd_sc_hd__a211o_1 A1 A2 B1 C1 VGND VNB VPB VPWR X
.ends

* Black-box entry subcircuit for sky130_fd_sc_hd__and3b_2 abstract view
.subckt sky130_fd_sc_hd__and3b_2 A_N B C VGND VNB VPB VPWR X
.ends

* Black-box entry subcircuit for sky130_fd_sc_hd__clkbuf_2 abstract view
.subckt sky130_fd_sc_hd__clkbuf_2 A VGND VNB VPB VPWR X
.ends

* Black-box entry subcircuit for sky130_fd_sc_hd__buf_4 abstract view
.subckt sky130_fd_sc_hd__buf_4 A VGND VNB VPB VPWR X
.ends

* Black-box entry subcircuit for sky130_fd_sc_hd__a311o_1 abstract view
.subckt sky130_fd_sc_hd__a311o_1 A1 A2 A3 B1 C1 VGND VNB VPB VPWR X
.ends

* Black-box entry subcircuit for sky130_fd_sc_hd__nand4_1 abstract view
.subckt sky130_fd_sc_hd__nand4_1 A B C D VGND VNB VPB VPWR Y
.ends

* Black-box entry subcircuit for sky130_fd_sc_hd__or2_2 abstract view
.subckt sky130_fd_sc_hd__or2_2 A B VGND VNB VPB VPWR X
.ends

* Black-box entry subcircuit for sky130_fd_sc_hd__xnor2_2 abstract view
.subckt sky130_fd_sc_hd__xnor2_2 A B VGND VNB VPB VPWR Y
.ends

* Black-box entry subcircuit for sky130_fd_sc_hd__and3b_1 abstract view
.subckt sky130_fd_sc_hd__and3b_1 A_N B C VGND VNB VPB VPWR X
.ends

* Black-box entry subcircuit for sky130_fd_sc_hd__nand3_1 abstract view
.subckt sky130_fd_sc_hd__nand3_1 A B C VGND VNB VPB VPWR Y
.ends

* Black-box entry subcircuit for sky130_fd_sc_hd__inv_2 abstract view
.subckt sky130_fd_sc_hd__inv_2 A VGND VNB VPB VPWR Y
.ends

* Black-box entry subcircuit for sky130_fd_sc_hd__a211oi_1 abstract view
.subckt sky130_fd_sc_hd__a211oi_1 A1 A2 B1 C1 VGND VNB VPB VPWR Y
.ends

* Black-box entry subcircuit for sky130_fd_sc_hd__and4bb_2 abstract view
.subckt sky130_fd_sc_hd__and4bb_2 A_N B_N C D VGND VNB VPB VPWR X
.ends

* Black-box entry subcircuit for sky130_fd_sc_hd__or3b_1 abstract view
.subckt sky130_fd_sc_hd__or3b_1 A B C_N VGND VNB VPB VPWR X
.ends

* Black-box entry subcircuit for sky130_fd_sc_hd__o21a_1 abstract view
.subckt sky130_fd_sc_hd__o21a_1 A1 A2 B1 VGND VNB VPB VPWR X
.ends

* Black-box entry subcircuit for sky130_fd_sc_hd__o211ai_2 abstract view
.subckt sky130_fd_sc_hd__o211ai_2 A1 A2 B1 C1 VGND VNB VPB VPWR Y
.ends

* Black-box entry subcircuit for sky130_fd_sc_hd__a21oi_2 abstract view
.subckt sky130_fd_sc_hd__a21oi_2 A1 A2 B1 VGND VNB VPB VPWR Y
.ends

* Black-box entry subcircuit for sky130_fd_sc_hd__and4b_2 abstract view
.subckt sky130_fd_sc_hd__and4b_2 A_N B C D VGND VNB VPB VPWR X
.ends

* Black-box entry subcircuit for sky130_fd_sc_hd__nor4_1 abstract view
.subckt sky130_fd_sc_hd__nor4_1 A B C D VGND VNB VPB VPWR Y
.ends

* Black-box entry subcircuit for sky130_fd_sc_hd__mux2_2 abstract view
.subckt sky130_fd_sc_hd__mux2_2 A0 A1 S VGND VNB VPB VPWR X
.ends

* Black-box entry subcircuit for sky130_fd_sc_hd__dlymetal6s2s_1 abstract view
.subckt sky130_fd_sc_hd__dlymetal6s2s_1 A VGND VNB VPB VPWR X
.ends

* Black-box entry subcircuit for sky130_fd_sc_hd__a22o_1 abstract view
.subckt sky130_fd_sc_hd__a22o_1 A1 A2 B1 B2 VGND VNB VPB VPWR X
.ends

* Black-box entry subcircuit for sky130_fd_sc_hd__nor3_1 abstract view
.subckt sky130_fd_sc_hd__nor3_1 A B C VGND VNB VPB VPWR Y
.ends

* Black-box entry subcircuit for sky130_fd_sc_hd__buf_6 abstract view
.subckt sky130_fd_sc_hd__buf_6 A VGND VNB VPB VPWR X
.ends

* Black-box entry subcircuit for sky130_fd_sc_hd__a2111o_1 abstract view
.subckt sky130_fd_sc_hd__a2111o_1 A1 A2 B1 C1 D1 VGND VNB VPB VPWR X
.ends

* Black-box entry subcircuit for sky130_fd_sc_hd__buf_1 abstract view
.subckt sky130_fd_sc_hd__buf_1 A VGND VNB VPB VPWR X
.ends

* Black-box entry subcircuit for sky130_fd_sc_hd__o21ba_1 abstract view
.subckt sky130_fd_sc_hd__o21ba_1 A1 A2 B1_N VGND VNB VPB VPWR X
.ends

* Black-box entry subcircuit for sky130_fd_sc_hd__clkbuf_1 abstract view
.subckt sky130_fd_sc_hd__clkbuf_1 A VGND VNB VPB VPWR X
.ends

* Black-box entry subcircuit for sky130_fd_sc_hd__a211o_2 abstract view
.subckt sky130_fd_sc_hd__a211o_2 A1 A2 B1 C1 VGND VNB VPB VPWR X
.ends

* Black-box entry subcircuit for sky130_fd_sc_hd__or4b_4 abstract view
.subckt sky130_fd_sc_hd__or4b_4 A B C D_N VGND VNB VPB VPWR X
.ends

* Black-box entry subcircuit for sky130_fd_sc_hd__a31oi_1 abstract view
.subckt sky130_fd_sc_hd__a31oi_1 A1 A2 A3 B1 VGND VNB VPB VPWR Y
.ends

* Black-box entry subcircuit for sky130_fd_sc_hd__o32a_1 abstract view
.subckt sky130_fd_sc_hd__o32a_1 A1 A2 A3 B1 B2 VGND VNB VPB VPWR X
.ends

* Black-box entry subcircuit for sky130_fd_sc_hd__o221a_1 abstract view
.subckt sky130_fd_sc_hd__o221a_1 A1 A2 B1 B2 C1 VGND VNB VPB VPWR X
.ends

* Black-box entry subcircuit for sky130_fd_sc_hd__or4b_1 abstract view
.subckt sky130_fd_sc_hd__or4b_1 A B C D_N VGND VNB VPB VPWR X
.ends

* Black-box entry subcircuit for sky130_fd_sc_hd__or4_1 abstract view
.subckt sky130_fd_sc_hd__or4_1 A B C D VGND VNB VPB VPWR X
.ends

* Black-box entry subcircuit for sky130_fd_sc_hd__o31ai_1 abstract view
.subckt sky130_fd_sc_hd__o31ai_1 A1 A2 A3 B1 VGND VNB VPB VPWR Y
.ends

* Black-box entry subcircuit for sky130_fd_sc_hd__a311oi_2 abstract view
.subckt sky130_fd_sc_hd__a311oi_2 A1 A2 A3 B1 C1 VGND VNB VPB VPWR Y
.ends

* Black-box entry subcircuit for sky130_fd_sc_hd__or3b_4 abstract view
.subckt sky130_fd_sc_hd__or3b_4 A B C_N VGND VNB VPB VPWR X
.ends

* Black-box entry subcircuit for sky130_fd_sc_hd__o41ai_4 abstract view
.subckt sky130_fd_sc_hd__o41ai_4 A1 A2 A3 A4 B1 VGND VNB VPB VPWR Y
.ends

* Black-box entry subcircuit for sky130_fd_sc_hd__dlygate4sd1_1 abstract view
.subckt sky130_fd_sc_hd__dlygate4sd1_1 A VGND VNB VPB VPWR X
.ends

* Black-box entry subcircuit for sky130_fd_sc_hd__a2111oi_1 abstract view
.subckt sky130_fd_sc_hd__a2111oi_1 A1 A2 B1 C1 D1 VGND VNB VPB VPWR Y
.ends

* Black-box entry subcircuit for sky130_fd_sc_hd__o2111a_1 abstract view
.subckt sky130_fd_sc_hd__o2111a_1 A1 A2 B1 C1 D1 VGND VNB VPB VPWR X
.ends

* Black-box entry subcircuit for sky130_fd_sc_hd__a31oi_2 abstract view
.subckt sky130_fd_sc_hd__a31oi_2 A1 A2 A3 B1 VGND VNB VPB VPWR Y
.ends

* Black-box entry subcircuit for sky130_fd_sc_hd__nand4b_1 abstract view
.subckt sky130_fd_sc_hd__nand4b_1 A_N B C D VGND VNB VPB VPWR Y
.ends

.subckt alu8bit VGND VPWR inst[0] inst[1] inst[2] inst[3] op_a[0] op_a[1] op_a[2]
+ op_a[3] op_a[4] op_a[5] op_a[6] op_a[7] op_b[0] op_b[1] op_b[2] op_b[3] op_b[4]
+ op_b[5] op_b[6] op_b[7] op_out[0] op_out[1] op_out[2] op_out[3] op_out[4] op_out[5]
+ op_out[6] op_out[7]
XFILLER_39_244 VPWR VGND VPWR VGND sky130_ef_sc_hd__decap_12
XFILLER_22_111 VPWR VGND VPWR VGND sky130_ef_sc_hd__decap_12
XFILLER_13_111 VGND VGND VPWR VPWR sky130_fd_sc_hd__fill_1
X_501_ _428_ _429_ VGND VGND VPWR VPWR _430_ sky130_fd_sc_hd__nor2_1
XFILLER_26_41 VGND VGND VPWR VPWR sky130_fd_sc_hd__decap_6
XFILLER_26_85 VPWR VGND VPWR VGND sky130_ef_sc_hd__decap_12
XFILLER_9_137 VPWR VGND VPWR VGND sky130_ef_sc_hd__decap_12
XFILLER_13_188 VGND VGND VPWR VPWR sky130_fd_sc_hd__fill_1
XFILLER_42_228 VPWR VGND VPWR VGND sky130_ef_sc_hd__decap_12
XFILLER_27_203 VPWR VGND VPWR VGND sky130_ef_sc_hd__decap_12
XFILLER_27_247 VPWR VGND VPWR VGND sky130_ef_sc_hd__decap_12
XFILLER_12_65 VPWR VGND VPWR VGND sky130_ef_sc_hd__decap_12
XTAP_TAPCELL_ROW_20_186 VGND VPWR sky130_fd_sc_hd__tapvpwrvgnd_1
XTAP_TAPCELL_ROW_28_220 VGND VPWR sky130_fd_sc_hd__tapvpwrvgnd_1
XTAP_TAPCELL_ROW_43_289 VGND VPWR sky130_fd_sc_hd__tapvpwrvgnd_1
XTAP_TAPCELL_ROW_11_142 VGND VPWR sky130_fd_sc_hd__tapvpwrvgnd_1
XFILLER_32_250 VGND VGND VPWR VPWR sky130_fd_sc_hd__fill_2
XTAP_TAPCELL_ROW_34_245 VGND VPWR sky130_fd_sc_hd__tapvpwrvgnd_1
XFILLER_30_209 VGND VGND VPWR VPWR sky130_fd_sc_hd__decap_8
XFILLER_2_121 VPWR VGND VPWR VGND sky130_ef_sc_hd__decap_12
XFILLER_2_165 VPWR VGND VPWR VGND sky130_ef_sc_hd__decap_12
X_895_ net40 net53 VGND VGND VPWR VPWR _377_ sky130_fd_sc_hd__nand2_1
XFILLER_0_57 VPWR VGND VPWR VGND sky130_ef_sc_hd__decap_12
XFILLER_9_55 VGND VGND VPWR VPWR sky130_fd_sc_hd__fill_1
XFILLER_12_209 VPWR VGND VPWR VGND sky130_ef_sc_hd__decap_12
XFILLER_20_253 VGND VGND VPWR VPWR sky130_fd_sc_hd__decap_3
X_680_ net65 net64 _317_ VGND VGND VPWR VPWR _151_ sky130_fd_sc_hd__or3_1
XFILLER_34_63 VPWR VGND VPWR VGND sky130_ef_sc_hd__decap_12
XFILLER_34_85 VGND VGND VPWR VPWR sky130_fd_sc_hd__decap_8
XFILLER_7_257 VGND VGND VPWR VPWR sky130_fd_sc_hd__fill_2
XFILLER_38_117 VPWR VGND VPWR VGND sky130_ef_sc_hd__decap_12
X_878_ _303_ _358_ VGND VGND VPWR VPWR _359_ sky130_fd_sc_hd__or2_1
X_732_ _176_ _202_ VGND VGND VPWR VPWR _203_ sky130_fd_sc_hd__and2_1
X_801_ net40 net56 net54 net42 VGND VGND VPWR VPWR _276_ sky130_fd_sc_hd__a22oi_1
XFILLER_29_41 VGND VGND VPWR VPWR sky130_fd_sc_hd__decap_3
XFILLER_43_175 VGND VGND VPWR VPWR sky130_fd_sc_hd__decap_3
XFILLER_43_153 VGND VGND VPWR VPWR sky130_fd_sc_hd__decap_4
X_594_ _027_ _029_ VGND VGND VPWR VPWR _065_ sky130_fd_sc_hd__xnor2_1
X_663_ net35 net43 VGND VGND VPWR VPWR _134_ sky130_fd_sc_hd__nand2_1
XFILLER_43_197 VGND VGND VPWR VPWR sky130_fd_sc_hd__fill_2
XFILLER_13_3 VPWR VGND VPWR VGND sky130_ef_sc_hd__decap_12
XFILLER_34_197 VGND VGND VPWR VPWR sky130_fd_sc_hd__decap_3
XFILLER_25_120 VGND VGND VPWR VPWR sky130_fd_sc_hd__fill_1
XFILLER_31_53 VGND VGND VPWR VPWR sky130_fd_sc_hd__decap_3
X_715_ _147_ _184_ VGND VGND VPWR VPWR _185_ sky130_fd_sc_hd__or2_1
X_646_ net55 _116_ VGND VGND VPWR VPWR _117_ sky130_fd_sc_hd__or2_1
XFILLER_16_153 VPWR VGND VPWR VGND sky130_ef_sc_hd__decap_12
XFILLER_16_197 VPWR VGND VPWR VGND sky130_ef_sc_hd__decap_12
X_577_ _045_ _046_ VGND VGND VPWR VPWR _048_ sky130_fd_sc_hd__nor2_1
XFILLER_39_223 VGND VGND VPWR VPWR sky130_fd_sc_hd__fill_1
XFILLER_39_212 VGND VGND VPWR VPWR sky130_fd_sc_hd__fill_1
XFILLER_39_256 VGND VGND VPWR VPWR sky130_fd_sc_hd__decap_3
XTAP_TAPCELL_ROW_17_170 VGND VPWR sky130_fd_sc_hd__tapvpwrvgnd_1
XFILLER_22_123 VGND VGND VPWR VPWR sky130_fd_sc_hd__decap_8
XFILLER_22_189 VGND VGND VPWR VPWR sky130_fd_sc_hd__fill_2
X_500_ _425_ _426_ _263_ VGND VGND VPWR VPWR _429_ sky130_fd_sc_hd__a21oi_1
XFILLER_9_105 VGND VGND VPWR VPWR sky130_fd_sc_hd__decap_6
XFILLER_13_167 VGND VGND VPWR VPWR sky130_fd_sc_hd__fill_1
XFILLER_26_20 VGND VGND VPWR VPWR sky130_fd_sc_hd__decap_8
XFILLER_26_97 VGND VGND VPWR VPWR sky130_fd_sc_hd__decap_4
XFILLER_42_85 VPWR VGND VPWR VGND sky130_ef_sc_hd__decap_12
XFILLER_42_41 VPWR VGND VPWR VGND sky130_ef_sc_hd__decap_12
XFILLER_9_149 VPWR VGND VPWR VGND sky130_ef_sc_hd__decap_12
XFILLER_3_57 VPWR VGND VPWR VGND sky130_ef_sc_hd__decap_12
XFILLER_36_248 VGND VGND VPWR VPWR sky130_fd_sc_hd__decap_4
X_629_ _064_ net29 VGND VGND VPWR VPWR _100_ sky130_fd_sc_hd__nor2_1
XTAP_TAPCELL_ROW_6_119 VGND VPWR sky130_fd_sc_hd__tapvpwrvgnd_1
XFILLER_27_215 VGND VGND VPWR VPWR sky130_fd_sc_hd__decap_4
XFILLER_12_77 VGND VGND VPWR VPWR sky130_fd_sc_hd__decap_6
XTAP_TAPCELL_ROW_28_221 VGND VPWR sky130_fd_sc_hd__tapvpwrvgnd_1
XFILLER_41_240 VGND VGND VPWR VPWR sky130_fd_sc_hd__fill_1
XTAP_TAPCELL_ROW_11_143 VGND VPWR sky130_fd_sc_hd__tapvpwrvgnd_1
XTAP_TAPCELL_ROW_34_246 VGND VPWR sky130_fd_sc_hd__tapvpwrvgnd_1
XPHY_EDGE_ROW_12_Right_12 VGND VGND VPWR VPWR sky130_fd_sc_hd__decap_3
XPHY_EDGE_ROW_21_Right_21 VGND VGND VPWR VPWR sky130_fd_sc_hd__decap_3
XFILLER_23_54 VGND VGND VPWR VPWR sky130_fd_sc_hd__fill_2
XFILLER_23_251 VGND VGND VPWR VPWR sky130_fd_sc_hd__decap_8
XPHY_EDGE_ROW_30_Right_30 VGND VGND VPWR VPWR sky130_fd_sc_hd__decap_3
XFILLER_2_133 VGND VGND VPWR VPWR sky130_fd_sc_hd__decap_6
XFILLER_2_177 VPWR VGND VPWR VGND sky130_ef_sc_hd__decap_12
X_894_ _352_ _354_ VGND VGND VPWR VPWR _376_ sky130_fd_sc_hd__and2b_1
XFILLER_0_69 VPWR VGND VPWR VGND sky130_ef_sc_hd__decap_12
XFILLER_14_251 VGND VGND VPWR VPWR sky130_fd_sc_hd__fill_1
XFILLER_43_3 VPWR VGND VPWR VGND sky130_ef_sc_hd__decap_12
XTAP_TAPCELL_ROW_0_90 VGND VPWR sky130_fd_sc_hd__tapvpwrvgnd_1
XFILLER_20_221 VPWR VGND VPWR VGND sky130_ef_sc_hd__decap_12
XFILLER_7_225 VPWR VGND VPWR VGND sky130_ef_sc_hd__decap_12
XFILLER_34_75 VGND VGND VPWR VPWR sky130_fd_sc_hd__decap_8
XFILLER_38_129 VGND VGND VPWR VPWR sky130_fd_sc_hd__decap_8
X_877_ _298_ _357_ VGND VGND VPWR VPWR _358_ sky130_fd_sc_hd__xnor2_1
XFILLER_37_173 VPWR VGND VPWR VGND sky130_ef_sc_hd__decap_12
XFILLER_20_66 VGND VGND VPWR VPWR sky130_fd_sc_hd__decap_4
XFILLER_20_88 VPWR VGND VPWR VGND sky130_ef_sc_hd__decap_12
X_731_ _200_ _201_ VGND VGND VPWR VPWR _202_ sky130_fd_sc_hd__nor2_1
X_800_ net42 net40 net56 net54 VGND VGND VPWR VPWR _275_ sky130_fd_sc_hd__and4_1
X_662_ _132_ _130_ VGND VGND VPWR VPWR _133_ sky130_fd_sc_hd__nand2b_1
X_593_ _033_ _063_ _061_ VGND VGND VPWR VPWR _064_ sky130_fd_sc_hd__mux2_1
XFILLER_28_195 VGND VGND VPWR VPWR sky130_fd_sc_hd__fill_1
XFILLER_34_132 VGND VGND VPWR VPWR sky130_fd_sc_hd__decap_8
XFILLER_34_165 VGND VGND VPWR VPWR sky130_fd_sc_hd__fill_2
XPHY_EDGE_ROW_6_Right_6 VGND VGND VPWR VPWR sky130_fd_sc_hd__decap_3
XFILLER_40_102 VGND VGND VPWR VPWR sky130_fd_sc_hd__fill_2
XFILLER_15_55 VGND VGND VPWR VPWR sky130_fd_sc_hd__fill_1
XFILLER_40_179 VPWR VGND VPWR VGND sky130_ef_sc_hd__decap_12
Xoutput21 net21 VGND VGND VPWR VPWR op_out[0] sky130_fd_sc_hd__buf_2
XFILLER_0_253 VGND VGND VPWR VPWR sky130_fd_sc_hd__decap_6
X_714_ net43 _182_ VGND VGND VPWR VPWR _184_ sky130_fd_sc_hd__xnor2_1
X_645_ _090_ _115_ net29 VGND VGND VPWR VPWR _116_ sky130_fd_sc_hd__mux2_1
X_576_ _042_ _043_ _252_ VGND VGND VPWR VPWR _047_ sky130_fd_sc_hd__a21o_1
XTAP_TAPCELL_ROW_17_171 VGND VPWR sky130_fd_sc_hd__tapvpwrvgnd_1
XFILLER_22_168 VGND VGND VPWR VPWR sky130_fd_sc_hd__fill_1
XFILLER_42_53 VPWR VGND VPWR VGND sky130_ef_sc_hd__decap_12
XFILLER_13_113 VPWR VGND VPWR VGND sky130_ef_sc_hd__decap_12
XFILLER_42_97 VPWR VGND VPWR VGND sky130_ef_sc_hd__decap_12
XTAP_TAPCELL_ROW_23_196 VGND VPWR sky130_fd_sc_hd__tapvpwrvgnd_1
XFILLER_3_69 VPWR VGND VPWR VGND sky130_ef_sc_hd__decap_12
X_628_ _095_ _098_ net48 VGND VGND VPWR VPWR _099_ sky130_fd_sc_hd__a21oi_4
X_559_ _026_ _028_ _025_ VGND VGND VPWR VPWR _030_ sky130_fd_sc_hd__o21ai_2
XPHY_EDGE_ROW_19_Left_63 VGND VGND VPWR VPWR sky130_fd_sc_hd__decap_3
XFILLER_6_109 VPWR VGND VPWR VGND sky130_ef_sc_hd__decap_12
XFILLER_37_86 VPWR VGND VPWR VGND sky130_ef_sc_hd__decap_12
XTAP_TAPCELL_ROW_28_222 VGND VPWR sky130_fd_sc_hd__tapvpwrvgnd_1
XTAP_TAPCELL_ROW_11_144 VGND VPWR sky130_fd_sc_hd__tapvpwrvgnd_1
XTAP_TAPCELL_ROW_34_247 VGND VPWR sky130_fd_sc_hd__tapvpwrvgnd_1
XTAP_TAPCELL_ROW_2_101 VGND VPWR sky130_fd_sc_hd__tapvpwrvgnd_1
XPHY_EDGE_ROW_4_Left_48 VGND VGND VPWR VPWR sky130_fd_sc_hd__decap_3
XFILLER_23_241 VGND VGND VPWR VPWR sky130_fd_sc_hd__decap_3
XFILLER_3_3 VPWR VGND VPWR VGND sky130_ef_sc_hd__decap_12
XFILLER_2_189 VGND VGND VPWR VPWR sky130_fd_sc_hd__decap_6
XFILLER_0_15 VPWR VGND VPWR VGND sky130_ef_sc_hd__decap_12
X_893_ _330_ _356_ VGND VGND VPWR VPWR _375_ sky130_fd_sc_hd__xnor2_1
XFILLER_9_57 VPWR VGND VPWR VGND sky130_ef_sc_hd__decap_12
XTAP_TAPCELL_ROW_0_91 VGND VPWR sky130_fd_sc_hd__tapvpwrvgnd_1
XFILLER_20_233 VGND VGND VPWR VPWR sky130_fd_sc_hd__fill_2
XFILLER_7_237 VPWR VGND VPWR VGND sky130_ef_sc_hd__decap_12
XFILLER_11_255 VGND VGND VPWR VPWR sky130_fd_sc_hd__fill_1
X_876_ _329_ _355_ VGND VGND VPWR VPWR _357_ sky130_fd_sc_hd__xnor2_1
XFILLER_37_185 VPWR VGND VPWR VGND sky130_ef_sc_hd__decap_12
XFILLER_37_141 VPWR VGND VPWR VGND sky130_ef_sc_hd__decap_12
X_730_ _198_ net60 net45 _196_ VGND VGND VPWR VPWR _201_ sky130_fd_sc_hd__and4b_1
X_592_ _035_ _062_ VGND VGND VPWR VPWR _063_ sky130_fd_sc_hd__xor2_1
XFILLER_28_141 VPWR VGND VPWR VGND sky130_ef_sc_hd__decap_12
X_661_ _124_ _125_ _131_ VGND VGND VPWR VPWR _132_ sky130_fd_sc_hd__or3_1
XFILLER_43_188 VGND VGND VPWR VPWR sky130_fd_sc_hd__fill_2
XPHY_EDGE_ROW_7_Left_51 VGND VGND VPWR VPWR sky130_fd_sc_hd__decap_3
X_859_ net36 net60 VGND VGND VPWR VPWR _339_ sky130_fd_sc_hd__nand2_1
XFILLER_25_144 VGND VGND VPWR VPWR sky130_fd_sc_hd__fill_1
XFILLER_25_188 VGND VGND VPWR VPWR sky130_fd_sc_hd__fill_2
XFILLER_31_22 VGND VGND VPWR VPWR sky130_fd_sc_hd__decap_3
XFILLER_31_44 VGND VGND VPWR VPWR sky130_fd_sc_hd__fill_2
XPHY_EDGE_ROW_33_Left_77 VGND VGND VPWR VPWR sky130_fd_sc_hd__decap_3
Xoutput22 net22 VGND VGND VPWR VPWR op_out[1] sky130_fd_sc_hd__buf_2
XFILLER_0_221 VGND VGND VPWR VPWR sky130_fd_sc_hd__decap_3
X_713_ net43 _182_ VGND VGND VPWR VPWR _183_ sky130_fd_sc_hd__nand2_1
XFILLER_16_122 VGND VGND VPWR VPWR sky130_fd_sc_hd__fill_1
X_575_ _042_ _043_ _252_ VGND VGND VPWR VPWR _046_ sky130_fd_sc_hd__a21oi_1
X_644_ _080_ _091_ VGND VGND VPWR VPWR _115_ sky130_fd_sc_hd__xnor2_1
XFILLER_31_136 VGND VGND VPWR VPWR sky130_fd_sc_hd__fill_2
XFILLER_39_225 VGND VGND VPWR VPWR sky130_fd_sc_hd__decap_4
XTAP_TAPCELL_ROW_17_172 VGND VPWR sky130_fd_sc_hd__tapvpwrvgnd_1
XFILLER_22_103 VGND VGND VPWR VPWR sky130_fd_sc_hd__decap_4
XFILLER_42_65 VPWR VGND VPWR VGND sky130_ef_sc_hd__decap_12
XFILLER_13_125 VGND VGND VPWR VPWR sky130_fd_sc_hd__decap_6
XFILLER_13_169 VPWR VGND VPWR VGND sky130_ef_sc_hd__decap_12
XTAP_TAPCELL_ROW_23_197 VGND VPWR sky130_fd_sc_hd__tapvpwrvgnd_1
XFILLER_3_15 VPWR VGND VPWR VGND sky130_ef_sc_hd__decap_12
X_558_ net35 net41 VGND VGND VPWR VPWR _029_ sky130_fd_sc_hd__or2_1
X_627_ _069_ _079_ _093_ _097_ VGND VGND VPWR VPWR _098_ sky130_fd_sc_hd__o31a_1
XFILLER_8_195 VGND VGND VPWR VPWR sky130_fd_sc_hd__fill_1
X_489_ net35 net69 VGND VGND VPWR VPWR _418_ sky130_fd_sc_hd__or2_1
XFILLER_10_139 VGND VGND VPWR VPWR sky130_fd_sc_hd__fill_1
XFILLER_37_98 VPWR VGND VPWR VGND sky130_ef_sc_hd__decap_12
XFILLER_37_54 VGND VGND VPWR VPWR sky130_fd_sc_hd__fill_2
XTAP_TAPCELL_ROW_11_145 VGND VPWR sky130_fd_sc_hd__tapvpwrvgnd_1
XPHY_EDGE_ROW_36_Left_80 VGND VGND VPWR VPWR sky130_fd_sc_hd__decap_3
XPHY_EDGE_ROW_20_Left_64 VGND VGND VPWR VPWR sky130_fd_sc_hd__decap_3
XTAP_TAPCELL_ROW_42_281 VGND VPWR sky130_fd_sc_hd__tapvpwrvgnd_1
XFILLER_32_253 VGND VGND VPWR VPWR sky130_fd_sc_hd__fill_2
XTAP_TAPCELL_ROW_34_248 VGND VPWR sky130_fd_sc_hd__tapvpwrvgnd_1
XTAP_TAPCELL_ROW_2_102 VGND VPWR sky130_fd_sc_hd__tapvpwrvgnd_1
XFILLER_23_231 VGND VGND VPWR VPWR sky130_fd_sc_hd__decap_4
XFILLER_23_78 VGND VGND VPWR VPWR sky130_fd_sc_hd__fill_2
XFILLER_0_27 VGND VGND VPWR VPWR sky130_fd_sc_hd__fill_1
X_892_ _299_ _303_ _357_ VGND VGND VPWR VPWR _374_ sky130_fd_sc_hd__o21ai_1
XFILLER_9_69 VPWR VGND VPWR VGND sky130_ef_sc_hd__decap_12
XFILLER_14_231 VPWR VGND VPWR VGND sky130_ef_sc_hd__decap_12
XFILLER_14_253 VGND VGND VPWR VPWR sky130_fd_sc_hd__decap_3
XTAP_TAPCELL_ROW_0_92 VGND VPWR sky130_fd_sc_hd__tapvpwrvgnd_1
XFILLER_29_3 VPWR VGND VPWR VGND sky130_ef_sc_hd__decap_12
XFILLER_18_56 VPWR VGND VPWR VGND sky130_ef_sc_hd__decap_12
XFILLER_11_223 VGND VGND VPWR VPWR sky130_fd_sc_hd__fill_1
XFILLER_34_44 VGND VGND VPWR VPWR sky130_fd_sc_hd__fill_2
XFILLER_7_249 VGND VGND VPWR VPWR sky130_fd_sc_hd__decap_8
XFILLER_7_205 VPWR VGND VPWR VGND sky130_ef_sc_hd__decap_12
X_875_ _329_ _353_ _354_ VGND VGND VPWR VPWR _356_ sky130_fd_sc_hd__and3_1
XFILLER_37_153 VGND VGND VPWR VPWR sky130_fd_sc_hd__decap_6
XFILLER_1_81 VPWR VGND VPWR VGND sky130_ef_sc_hd__decap_12
XFILLER_43_134 VGND VGND VPWR VPWR sky130_fd_sc_hd__fill_2
X_591_ _030_ _048_ _055_ _058_ VGND VGND VPWR VPWR _062_ sky130_fd_sc_hd__a31o_1
XFILLER_28_131 VGND VGND VPWR VPWR sky130_fd_sc_hd__decap_8
XFILLER_28_153 VGND VGND VPWR VPWR sky130_fd_sc_hd__decap_4
XFILLER_28_175 VPWR VGND VPWR VGND sky130_ef_sc_hd__decap_12
XFILLER_28_197 VGND VGND VPWR VPWR sky130_fd_sc_hd__fill_2
XFILLER_29_55 VGND VGND VPWR VPWR sky130_fd_sc_hd__fill_1
XFILLER_29_77 VGND VGND VPWR VPWR sky130_fd_sc_hd__fill_2
X_660_ _067_ _099_ _128_ _252_ VGND VGND VPWR VPWR _131_ sky130_fd_sc_hd__o211a_1
XFILLER_43_167 VGND VGND VPWR VPWR sky130_fd_sc_hd__fill_1
XFILLER_6_15 VPWR VGND VPWR VGND sky130_ef_sc_hd__decap_12
X_858_ _333_ _336_ VGND VGND VPWR VPWR _337_ sky130_fd_sc_hd__xnor2_1
X_789_ _261_ _262_ VGND VGND VPWR VPWR _264_ sky130_fd_sc_hd__and2_1
XFILLER_34_189 VGND VGND VPWR VPWR sky130_fd_sc_hd__fill_1
XFILLER_15_57 VPWR VGND VPWR VGND sky130_ef_sc_hd__decap_12
Xoutput23 net23 VGND VGND VPWR VPWR op_out[2] sky130_fd_sc_hd__buf_2
X_712_ _242_ _181_ VGND VGND VPWR VPWR _182_ sky130_fd_sc_hd__xnor2_1
X_643_ net52 _112_ VGND VGND VPWR VPWR _114_ sky130_fd_sc_hd__nand2_1
X_574_ _252_ _042_ _043_ VGND VGND VPWR VPWR _045_ sky130_fd_sc_hd__and3_1
XFILLER_11_3 VPWR VGND VPWR VGND sky130_ef_sc_hd__decap_12
XFILLER_26_12 VGND VGND VPWR VPWR sky130_fd_sc_hd__fill_1
XFILLER_26_56 VPWR VGND VPWR VGND sky130_ef_sc_hd__decap_12
XFILLER_42_77 VGND VGND VPWR VPWR sky130_fd_sc_hd__decap_6
XFILLER_13_137 VPWR VGND VPWR VGND sky130_ef_sc_hd__decap_12
XTAP_TAPCELL_ROW_23_198 VGND VPWR sky130_fd_sc_hd__tapvpwrvgnd_1
XTAP_TAPCELL_ROW_8_130 VGND VPWR sky130_fd_sc_hd__tapvpwrvgnd_1
XFILLER_3_27 VPWR VGND VPWR VGND sky130_ef_sc_hd__decap_12
X_488_ net65 net69 VGND VGND VPWR VPWR _417_ sky130_fd_sc_hd__and2_1
X_557_ net35 net41 VGND VGND VPWR VPWR _028_ sky130_fd_sc_hd__nor2_1
X_626_ _273_ _082_ _096_ net52 VGND VGND VPWR VPWR _097_ sky130_fd_sc_hd__o2bb2a_1
XFILLER_8_141 VPWR VGND VPWR VGND sky130_ef_sc_hd__decap_12
XFILLER_26_240 VGND VGND VPWR VPWR sky130_fd_sc_hd__fill_1
XFILLER_5_111 VGND VGND VPWR VPWR sky130_fd_sc_hd__fill_1
X_609_ _069_ _079_ VGND VGND VPWR VPWR _080_ sky130_fd_sc_hd__nor2_1
XTAP_TAPCELL_ROW_42_282 VGND VPWR sky130_fd_sc_hd__tapvpwrvgnd_1
XFILLER_32_221 VPWR VGND VPWR VGND sky130_ef_sc_hd__decap_12
XFILLER_32_243 VGND VGND VPWR VPWR sky130_fd_sc_hd__fill_2
XTAP_TAPCELL_ROW_34_249 VGND VPWR sky130_fd_sc_hd__tapvpwrvgnd_1
XTAP_TAPCELL_ROW_2_103 VGND VPWR sky130_fd_sc_hd__tapvpwrvgnd_1
XTAP_TAPCELL_ROW_25_205 VGND VPWR sky130_fd_sc_hd__tapvpwrvgnd_1
XFILLER_23_57 VPWR VGND VPWR VGND sky130_ef_sc_hd__decap_12
X_891_ _161_ _372_ VGND VGND VPWR VPWR _373_ sky130_fd_sc_hd__nor2_1
XFILLER_9_15 VPWR VGND VPWR VGND sky130_ef_sc_hd__decap_12
XFILLER_14_243 VGND VGND VPWR VPWR sky130_fd_sc_hd__decap_8
XTAP_TAPCELL_ROW_0_93 VGND VPWR sky130_fd_sc_hd__tapvpwrvgnd_1
XTAP_TAPCELL_ROW_30_230 VGND VPWR sky130_fd_sc_hd__tapvpwrvgnd_1
XFILLER_18_68 VGND VGND VPWR VPWR sky130_fd_sc_hd__decap_4
XFILLER_7_217 VGND VGND VPWR VPWR sky130_fd_sc_hd__decap_6
X_874_ _353_ _354_ VGND VGND VPWR VPWR _355_ sky130_fd_sc_hd__nand2_1
XFILLER_41_3 VPWR VGND VPWR VGND sky130_ef_sc_hd__decap_12
XFILLER_37_110 VGND VGND VPWR VPWR sky130_fd_sc_hd__fill_2
XFILLER_1_93 VPWR VGND VPWR VGND sky130_ef_sc_hd__decap_12
XFILLER_4_209 VPWR VGND VPWR VGND sky130_ef_sc_hd__decap_12
XFILLER_43_113 VGND VGND VPWR VPWR sky130_fd_sc_hd__fill_2
X_590_ _059_ _057_ _060_ net50 net48 VGND VGND VPWR VPWR _061_ sky130_fd_sc_hd__a311oi_4
XFILLER_28_121 VGND VGND VPWR VPWR sky130_fd_sc_hd__decap_4
XFILLER_28_187 VGND VGND VPWR VPWR sky130_fd_sc_hd__decap_8
XFILLER_6_27 VGND VGND VPWR VPWR sky130_fd_sc_hd__fill_1
X_857_ _334_ _335_ VGND VGND VPWR VPWR _336_ sky130_fd_sc_hd__nor2_1
X_788_ _229_ _232_ _260_ VGND VGND VPWR VPWR _262_ sky130_fd_sc_hd__or3_1
XFILLER_34_102 VGND VGND VPWR VPWR sky130_fd_sc_hd__fill_2
XFILLER_34_157 VGND VGND VPWR VPWR sky130_fd_sc_hd__decap_8
XFILLER_25_124 VPWR VGND VPWR VGND sky130_ef_sc_hd__decap_12
XFILLER_15_69 VPWR VGND VPWR VGND sky130_ef_sc_hd__decap_12
Xoutput24 net24 VGND VGND VPWR VPWR op_out[3] sky130_fd_sc_hd__buf_2
X_711_ net66 _160_ VGND VGND VPWR VPWR _181_ sky130_fd_sc_hd__nand2_1
X_642_ net52 _112_ VGND VGND VPWR VPWR _113_ sky130_fd_sc_hd__nor2_1
XFILLER_16_102 VPWR VGND VPWR VGND sky130_ef_sc_hd__decap_12
XPHY_EDGE_ROW_19_Right_19 VGND VGND VPWR VPWR sky130_fd_sc_hd__decap_3
X_573_ _042_ _043_ VGND VGND VPWR VPWR _044_ sky130_fd_sc_hd__nand2_1
XFILLER_31_116 VPWR VGND VPWR VGND sky130_ef_sc_hd__decap_12
XFILLER_31_149 VGND VGND VPWR VPWR sky130_fd_sc_hd__fill_1
XFILLER_21_90 VPWR VGND VPWR VGND sky130_ef_sc_hd__decap_12
XPHY_EDGE_ROW_28_Right_28 VGND VGND VPWR VPWR sky130_fd_sc_hd__decap_3
XPHY_EDGE_ROW_37_Right_37 VGND VGND VPWR VPWR sky130_fd_sc_hd__decap_3
X_909_ _387_ _391_ VGND VGND VPWR VPWR _393_ sky130_fd_sc_hd__xnor2_1
XFILLER_7_81 VPWR VGND VPWR VGND sky130_ef_sc_hd__decap_12
XFILLER_13_105 VGND VGND VPWR VPWR sky130_fd_sc_hd__decap_6
XFILLER_13_149 VPWR VGND VPWR VGND sky130_ef_sc_hd__decap_12
XFILLER_26_68 VPWR VGND VPWR VGND sky130_ef_sc_hd__decap_12
XTAP_TAPCELL_ROW_23_199 VGND VPWR sky130_fd_sc_hd__tapvpwrvgnd_1
XTAP_TAPCELL_ROW_8_131 VGND VPWR sky130_fd_sc_hd__tapvpwrvgnd_1
XFILLER_3_39 VPWR VGND VPWR VGND sky130_ef_sc_hd__decap_12
X_625_ _273_ _082_ _064_ VGND VGND VPWR VPWR _096_ sky130_fd_sc_hd__o21bai_1
XTAP_TAPCELL_ROW_14_155 VGND VPWR sky130_fd_sc_hd__tapvpwrvgnd_1
X_487_ net65 net69 VGND VGND VPWR VPWR _416_ sky130_fd_sc_hd__nor2_1
X_556_ _024_ _026_ VGND VGND VPWR VPWR _027_ sky130_fd_sc_hd__nor2_1
XFILLER_8_197 VPWR VGND VPWR VGND sky130_ef_sc_hd__decap_12
XFILLER_8_153 VPWR VGND VPWR VGND sky130_ef_sc_hd__decap_12
XFILLER_12_15 VPWR VGND VPWR VGND sky130_ef_sc_hd__decap_12
XFILLER_37_78 VGND VGND VPWR VPWR sky130_fd_sc_hd__decap_3
XFILLER_5_167 VGND VGND VPWR VPWR sky130_fd_sc_hd__fill_1
X_608_ _075_ _076_ _068_ _074_ VGND VGND VPWR VPWR _079_ sky130_fd_sc_hd__a211oi_2
XTAP_TAPCELL_ROW_42_283 VGND VPWR sky130_fd_sc_hd__tapvpwrvgnd_1
X_539_ _263_ _453_ _004_ _008_ _003_ VGND VGND VPWR VPWR _010_ sky130_fd_sc_hd__a221o_1
XFILLER_32_233 VGND VGND VPWR VPWR sky130_fd_sc_hd__fill_2
XTAP_TAPCELL_ROW_2_104 VGND VPWR sky130_fd_sc_hd__tapvpwrvgnd_1
XFILLER_23_36 VGND VGND VPWR VPWR sky130_fd_sc_hd__decap_6
XTAP_TAPCELL_ROW_25_206 VGND VPWR sky130_fd_sc_hd__tapvpwrvgnd_1
X_890_ _367_ _371_ VGND VGND VPWR VPWR _372_ sky130_fd_sc_hd__xnor2_1
XFILLER_0_29 VPWR VGND VPWR VGND sky130_ef_sc_hd__decap_12
XFILLER_9_27 VPWR VGND VPWR VGND sky130_ef_sc_hd__decap_12
XFILLER_36_6 VGND VGND VPWR VPWR sky130_fd_sc_hd__decap_8
XFILLER_1_181 VPWR VGND VPWR VGND sky130_ef_sc_hd__decap_12
XTAP_TAPCELL_ROW_0_94 VGND VPWR sky130_fd_sc_hd__tapvpwrvgnd_1
XTAP_TAPCELL_ROW_30_231 VGND VPWR sky130_fd_sc_hd__tapvpwrvgnd_1
XFILLER_11_225 VPWR VGND VPWR VGND sky130_ef_sc_hd__decap_12
XFILLER_1_3 VPWR VGND VPWR VGND sky130_ef_sc_hd__decap_12
X_873_ _332_ _351_ _352_ VGND VGND VPWR VPWR _354_ sky130_fd_sc_hd__or3_1
XFILLER_6_251 VGND VGND VPWR VPWR sky130_fd_sc_hd__fill_1
XFILLER_37_166 VGND VGND VPWR VPWR sky130_fd_sc_hd__fill_2
XFILLER_20_15 VPWR VGND VPWR VGND sky130_ef_sc_hd__decap_12
XFILLER_29_57 VGND VGND VPWR VPWR sky130_fd_sc_hd__fill_1
XFILLER_43_147 VGND VGND VPWR VPWR sky130_fd_sc_hd__decap_3
X_787_ _229_ _232_ _260_ VGND VGND VPWR VPWR _261_ sky130_fd_sc_hd__o21ai_1
XFILLER_19_122 VGND VGND VPWR VPWR sky130_fd_sc_hd__fill_1
XFILLER_19_166 VGND VGND VPWR VPWR sky130_fd_sc_hd__fill_2
X_856_ net38 net40 net56 net17 VGND VGND VPWR VPWR _335_ sky130_fd_sc_hd__and4_1
XFILLER_34_147 VGND VGND VPWR VPWR sky130_fd_sc_hd__decap_4
XFILLER_15_15 VPWR VGND VPWR VGND sky130_ef_sc_hd__decap_12
XFILLER_25_136 VGND VGND VPWR VPWR sky130_fd_sc_hd__decap_8
Xoutput25 net25 VGND VGND VPWR VPWR op_out[4] sky130_fd_sc_hd__buf_2
X_710_ _173_ _178_ _179_ VGND VGND VPWR VPWR _180_ sky130_fd_sc_hd__or3_1
X_641_ _086_ _111_ net29 VGND VGND VPWR VPWR _112_ sky130_fd_sc_hd__mux2_1
XFILLER_16_114 VGND VGND VPWR VPWR sky130_fd_sc_hd__decap_8
X_572_ _014_ _018_ _041_ VGND VGND VPWR VPWR _043_ sky130_fd_sc_hd__or3_1
XFILLER_31_128 VGND VGND VPWR VPWR sky130_fd_sc_hd__decap_8
XFILLER_39_206 VGND VGND VPWR VPWR sky130_fd_sc_hd__decap_6
X_908_ _388_ _390_ VGND VGND VPWR VPWR _391_ sky130_fd_sc_hd__xnor2_1
X_839_ net10 net53 _166_ _168_ net67 VGND VGND VPWR VPWR _318_ sky130_fd_sc_hd__a32o_1
XFILLER_15_191 VPWR VGND VPWR VGND sky130_ef_sc_hd__decap_12
XFILLER_22_139 VGND VGND VPWR VPWR sky130_fd_sc_hd__fill_1
XFILLER_30_150 VGND VGND VPWR VPWR sky130_fd_sc_hd__fill_2
XFILLER_30_161 VGND VGND VPWR VPWR sky130_fd_sc_hd__decap_8
XFILLER_7_93 VPWR VGND VPWR VGND sky130_ef_sc_hd__decap_12
XFILLER_38_250 VGND VGND VPWR VPWR sky130_fd_sc_hd__fill_2
XFILLER_21_183 VGND VGND VPWR VPWR sky130_fd_sc_hd__decap_6
XFILLER_21_194 VGND VGND VPWR VPWR sky130_fd_sc_hd__decap_8
XTAP_TAPCELL_ROW_8_132 VGND VPWR sky130_fd_sc_hd__tapvpwrvgnd_1
XFILLER_36_209 VPWR VGND VPWR VGND sky130_ef_sc_hd__decap_12
X_555_ net62 _020_ _021_ VGND VGND VPWR VPWR _026_ sky130_fd_sc_hd__and3_1
X_624_ _087_ _094_ _081_ _083_ VGND VGND VPWR VPWR _095_ sky130_fd_sc_hd__or4bb_4
XFILLER_8_121 VPWR VGND VPWR VGND sky130_ef_sc_hd__decap_12
XTAP_TAPCELL_ROW_14_156 VGND VPWR sky130_fd_sc_hd__tapvpwrvgnd_1
X_486_ net35 net36 VGND VGND VPWR VPWR _415_ sky130_fd_sc_hd__nor2_1
XFILLER_16_80 VGND VGND VPWR VPWR sky130_fd_sc_hd__decap_4
XFILLER_8_165 VPWR VGND VPWR VGND sky130_ef_sc_hd__decap_12
XTAP_TAPCELL_ROW_37_259 VGND VPWR sky130_fd_sc_hd__tapvpwrvgnd_1
XFILLER_10_109 VPWR VGND VPWR VGND sky130_ef_sc_hd__decap_12
XFILLER_12_27 VGND VGND VPWR VPWR sky130_fd_sc_hd__fill_1
XFILLER_26_253 VGND VGND VPWR VPWR sky130_fd_sc_hd__decap_6
XFILLER_5_113 VPWR VGND VPWR VGND sky130_ef_sc_hd__decap_12
X_538_ _004_ _008_ _003_ VGND VGND VPWR VPWR _009_ sky130_fd_sc_hd__a21oi_1
X_607_ _075_ _076_ _074_ VGND VGND VPWR VPWR _078_ sky130_fd_sc_hd__a21o_1
XTAP_TAPCELL_ROW_42_284 VGND VPWR sky130_fd_sc_hd__tapvpwrvgnd_1
X_469_ net52 net54 net48 net50 VGND VGND VPWR VPWR _306_ sky130_fd_sc_hd__or4_4
XFILLER_4_83 VGND VGND VPWR VPWR sky130_fd_sc_hd__fill_1
XTAP_TAPCELL_ROW_2_105 VGND VPWR sky130_fd_sc_hd__tapvpwrvgnd_1
XTAP_TAPCELL_ROW_25_207 VGND VPWR sky130_fd_sc_hd__tapvpwrvgnd_1
XFILLER_9_39 VPWR VGND VPWR VGND sky130_ef_sc_hd__decap_12
XFILLER_13_81 VPWR VGND VPWR VGND sky130_ef_sc_hd__decap_12
Xfanout60 net61 VGND VGND VPWR VPWR net60 sky130_fd_sc_hd__clkbuf_4
XPHY_EDGE_ROW_24_Left_68 VGND VGND VPWR VPWR sky130_fd_sc_hd__decap_3
XFILLER_1_193 VPWR VGND VPWR VGND sky130_ef_sc_hd__decap_12
XTAP_TAPCELL_ROW_0_95 VGND VPWR sky130_fd_sc_hd__tapvpwrvgnd_1
XFILLER_18_15 VPWR VGND VPWR VGND sky130_ef_sc_hd__decap_12
XFILLER_11_237 VPWR VGND VPWR VGND sky130_ef_sc_hd__decap_12
X_872_ _351_ _352_ _332_ VGND VGND VPWR VPWR _353_ sky130_fd_sc_hd__o21ai_1
XFILLER_1_51 VGND VGND VPWR VPWR sky130_fd_sc_hd__decap_4
XFILLER_20_27 VGND VGND VPWR VPWR sky130_fd_sc_hd__fill_1
XFILLER_43_126 VGND VGND VPWR VPWR sky130_fd_sc_hd__decap_8
XFILLER_6_29 VPWR VGND VPWR VGND sky130_ef_sc_hd__decap_12
XFILLER_19_134 VPWR VGND VPWR VGND sky130_ef_sc_hd__decap_12
X_855_ net38 net56 net17 net40 VGND VGND VPWR VPWR _334_ sky130_fd_sc_hd__a22oi_1
X_786_ _251_ _258_ VGND VGND VPWR VPWR _260_ sky130_fd_sc_hd__xnor2_1
XPHY_EDGE_ROW_27_Left_71 VGND VGND VPWR VPWR sky130_fd_sc_hd__decap_3
XFILLER_40_107 VPWR VGND VPWR VGND sky130_ef_sc_hd__decap_12
XPHY_EDGE_ROW_11_Left_55 VGND VGND VPWR VPWR sky130_fd_sc_hd__decap_3
XFILLER_15_27 VPWR VGND VPWR VGND sky130_ef_sc_hd__decap_12
Xoutput26 net26 VGND VGND VPWR VPWR op_out[5] sky130_fd_sc_hd__buf_2
XFILLER_0_225 VPWR VGND VPWR VGND sky130_ef_sc_hd__decap_12
XPHY_EDGE_ROW_1_Right_1 VGND VGND VPWR VPWR sky130_fd_sc_hd__decap_3
XFILLER_16_137 VGND VGND VPWR VPWR sky130_fd_sc_hd__decap_3
X_571_ _015_ net31 _453_ VGND VGND VPWR VPWR _042_ sky130_fd_sc_hd__a21o_1
X_640_ _088_ _110_ VGND VGND VPWR VPWR _111_ sky130_fd_sc_hd__xor2_1
X_907_ _340_ _389_ VGND VGND VPWR VPWR _390_ sky130_fd_sc_hd__xor2_1
X_838_ net10 net53 _157_ _315_ VGND VGND VPWR VPWR _316_ sky130_fd_sc_hd__o22a_1
X_769_ _295_ _019_ _240_ _241_ VGND VGND VPWR VPWR _243_ sky130_fd_sc_hd__a211o_1
XFILLER_22_107 VGND VGND VPWR VPWR sky130_fd_sc_hd__fill_1
X_485_ net65 net36 VGND VGND VPWR VPWR _414_ sky130_fd_sc_hd__or2_1
X_554_ _020_ _021_ net62 VGND VGND VPWR VPWR _025_ sky130_fd_sc_hd__a21o_1
X_623_ net55 _086_ _090_ net58 VGND VGND VPWR VPWR _094_ sky130_fd_sc_hd__o22a_1
XFILLER_8_177 VPWR VGND VPWR VGND sky130_ef_sc_hd__decap_12
XFILLER_8_133 VGND VGND VPWR VPWR sky130_fd_sc_hd__decap_6
XFILLER_12_195 VGND VGND VPWR VPWR sky130_fd_sc_hd__fill_1
XTAP_TAPCELL_ROW_14_157 VGND VPWR sky130_fd_sc_hd__tapvpwrvgnd_1
XFILLER_37_69 VGND VGND VPWR VPWR sky130_fd_sc_hd__fill_2
XFILLER_37_47 VGND VGND VPWR VPWR sky130_fd_sc_hd__fill_2
XFILLER_41_257 VGND VGND VPWR VPWR sky130_fd_sc_hd__fill_2
XFILLER_5_169 VPWR VGND VPWR VGND sky130_ef_sc_hd__decap_12
XFILLER_5_125 VPWR VGND VPWR VGND sky130_ef_sc_hd__decap_12
X_468_ net47 _284_ net3 VGND VGND VPWR VPWR _295_ sky130_fd_sc_hd__and3b_2
XFILLER_17_254 VGND VGND VPWR VPWR sky130_fd_sc_hd__fill_2
X_537_ net65 _210_ VGND VGND VPWR VPWR _008_ sky130_fd_sc_hd__nand2_1
X_606_ _075_ _076_ VGND VGND VPWR VPWR _077_ sky130_fd_sc_hd__nand2_1
XTAP_TAPCELL_ROW_42_285 VGND VPWR sky130_fd_sc_hd__tapvpwrvgnd_1
XFILLER_23_213 VGND VGND VPWR VPWR sky130_fd_sc_hd__fill_2
XTAP_TAPCELL_ROW_25_208 VGND VPWR sky130_fd_sc_hd__tapvpwrvgnd_1
XFILLER_23_235 VGND VGND VPWR VPWR sky130_fd_sc_hd__fill_1
XTAP_TAPCELL_ROW_33_241 VGND VPWR sky130_fd_sc_hd__tapvpwrvgnd_1
XFILLER_2_139 VGND VGND VPWR VPWR sky130_fd_sc_hd__fill_1
XFILLER_13_93 VPWR VGND VPWR VGND sky130_ef_sc_hd__decap_12
Xfanout61 net15 VGND VGND VPWR VPWR net61 sky130_fd_sc_hd__clkbuf_2
Xfanout50 net19 VGND VGND VPWR VPWR net50 sky130_fd_sc_hd__buf_4
XFILLER_1_161 VGND VGND VPWR VPWR sky130_fd_sc_hd__decap_6
XTAP_TAPCELL_ROW_0_96 VGND VPWR sky130_fd_sc_hd__tapvpwrvgnd_1
XFILLER_18_27 VGND VGND VPWR VPWR sky130_fd_sc_hd__fill_1
XPHY_EDGE_ROW_41_Left_85 VGND VGND VPWR VPWR sky130_fd_sc_hd__decap_3
XFILLER_11_205 VPWR VGND VPWR VGND sky130_ef_sc_hd__decap_12
XFILLER_34_26 VGND VGND VPWR VPWR sky130_fd_sc_hd__fill_2
XFILLER_11_249 VGND VGND VPWR VPWR sky130_fd_sc_hd__decap_6
X_871_ _288_ _291_ _350_ VGND VGND VPWR VPWR _352_ sky130_fd_sc_hd__a21oi_1
XFILLER_6_253 VGND VGND VPWR VPWR sky130_fd_sc_hd__decap_6
XFILLER_37_113 VPWR VGND VPWR VGND sky130_ef_sc_hd__decap_12
XFILLER_29_15 VGND VGND VPWR VPWR sky130_fd_sc_hd__decap_8
XFILLER_29_26 VGND VGND VPWR VPWR sky130_fd_sc_hd__decap_3
XFILLER_28_102 VGND VGND VPWR VPWR sky130_fd_sc_hd__fill_2
XFILLER_3_223 VGND VGND VPWR VPWR sky130_fd_sc_hd__fill_1
XFILLER_10_83 VGND VGND VPWR VPWR sky130_fd_sc_hd__fill_1
X_854_ net42 net53 VGND VGND VPWR VPWR _333_ sky130_fd_sc_hd__nand2_1
X_923_ net32 _401_ _402_ _407_ _373_ VGND VGND VPWR VPWR net28 sky130_fd_sc_hd__a311o_1
XFILLER_19_146 VPWR VGND VPWR VGND sky130_ef_sc_hd__decap_12
X_785_ _251_ _258_ VGND VGND VPWR VPWR _259_ sky130_fd_sc_hd__nand2b_1
XFILLER_40_119 VGND VGND VPWR VPWR sky130_fd_sc_hd__decap_6
XFILLER_15_39 VPWR VGND VPWR VGND sky130_ef_sc_hd__decap_12
XFILLER_25_116 VGND VGND VPWR VPWR sky130_fd_sc_hd__decap_4
XFILLER_0_237 VPWR VGND VPWR VGND sky130_ef_sc_hd__decap_12
Xoutput27 net27 VGND VGND VPWR VPWR op_out[6] sky130_fd_sc_hd__buf_2
X_570_ _009_ _040_ VGND VGND VPWR VPWR _041_ sky130_fd_sc_hd__xnor2_1
X_768_ net37 _168_ _236_ _237_ _239_ VGND VGND VPWR VPWR _241_ sky130_fd_sc_hd__a221o_1
X_906_ net65 net12 VGND VGND VPWR VPWR _389_ sky130_fd_sc_hd__nand2_1
X_837_ net10 net53 _159_ VGND VGND VPWR VPWR _315_ sky130_fd_sc_hd__a21oi_1
X_699_ _152_ _155_ _164_ _169_ _163_ VGND VGND VPWR VPWR _170_ sky130_fd_sc_hd__a311o_1
XFILLER_7_51 VGND VGND VPWR VPWR sky130_fd_sc_hd__decap_4
XFILLER_30_141 VGND VGND VPWR VPWR sky130_fd_sc_hd__fill_2
XPHY_EDGE_ROW_15_Right_15 VGND VGND VPWR VPWR sky130_fd_sc_hd__decap_3
XFILLER_38_230 VGND VGND VPWR VPWR sky130_fd_sc_hd__decap_4
XPHY_EDGE_ROW_24_Right_24 VGND VGND VPWR VPWR sky130_fd_sc_hd__decap_3
XFILLER_42_15 VPWR VGND VPWR VGND sky130_ef_sc_hd__decap_12
XFILLER_21_152 VPWR VGND VPWR VGND sky130_ef_sc_hd__decap_12
XPHY_EDGE_ROW_33_Right_33 VGND VGND VPWR VPWR sky130_fd_sc_hd__decap_3
XFILLER_29_230 VPWR VGND VPWR VGND sky130_ef_sc_hd__decap_12
X_622_ _081_ _083_ _088_ _091_ VGND VGND VPWR VPWR _093_ sky130_fd_sc_hd__nand4_1
XPHY_EDGE_ROW_42_Right_42 VGND VGND VPWR VPWR sky130_fd_sc_hd__decap_3
X_484_ net67 _410_ net34 VGND VGND VPWR VPWR _413_ sky130_fd_sc_hd__a21o_1
X_553_ net34 _022_ VGND VGND VPWR VPWR _024_ sky130_fd_sc_hd__and2_1
XFILLER_8_189 VGND VGND VPWR VPWR sky130_fd_sc_hd__decap_6
XFILLER_12_141 VPWR VGND VPWR VGND sky130_ef_sc_hd__decap_12
XTAP_TAPCELL_ROW_14_158 VGND VPWR sky130_fd_sc_hd__tapvpwrvgnd_1
XTAP_TAPCELL_ROW_22_191 VGND VPWR sky130_fd_sc_hd__tapvpwrvgnd_1
XFILLER_12_29 VPWR VGND VPWR VGND sky130_ef_sc_hd__decap_12
XFILLER_37_15 VPWR VGND VPWR VGND sky130_ef_sc_hd__decap_12
XTAP_TAPCELL_ROW_5_115 VGND VPWR sky130_fd_sc_hd__tapvpwrvgnd_1
XFILLER_26_200 VPWR VGND VPWR VGND sky130_ef_sc_hd__decap_12
XFILLER_5_137 VPWR VGND VPWR VGND sky130_ef_sc_hd__decap_12
X_605_ net35 net43 VGND VGND VPWR VPWR _076_ sky130_fd_sc_hd__or2_2
X_467_ net1 net2 VGND VGND VPWR VPWR _284_ sky130_fd_sc_hd__nor2_1
X_536_ net35 _210_ VGND VGND VPWR VPWR _007_ sky130_fd_sc_hd__nor2_1
XFILLER_4_85 VPWR VGND VPWR VGND sky130_ef_sc_hd__decap_12
XFILLER_4_41 VPWR VGND VPWR VGND sky130_ef_sc_hd__decap_12
XTAP_TAPCELL_ROW_33_242 VGND VPWR sky130_fd_sc_hd__tapvpwrvgnd_1
Xfanout40 net41 VGND VGND VPWR VPWR net40 sky130_fd_sc_hd__buf_2
Xfanout62 net64 VGND VGND VPWR VPWR net62 sky130_fd_sc_hd__clkbuf_4
Xfanout51 net19 VGND VGND VPWR VPWR net51 sky130_fd_sc_hd__clkbuf_2
X_519_ _252_ _446_ VGND VGND VPWR VPWR _448_ sky130_fd_sc_hd__xnor2_2
XFILLER_11_217 VGND VGND VPWR VPWR sky130_fd_sc_hd__decap_6
X_870_ _288_ _291_ _350_ VGND VGND VPWR VPWR _351_ sky130_fd_sc_hd__and3_1
XFILLER_6_221 VPWR VGND VPWR VGND sky130_ef_sc_hd__decap_12
XFILLER_37_125 VGND VGND VPWR VPWR sky130_fd_sc_hd__fill_1
XFILLER_34_6 VPWR VGND VPWR VGND sky130_ef_sc_hd__decap_12
XFILLER_20_29 VPWR VGND VPWR VGND sky130_ef_sc_hd__decap_12
XFILLER_3_257 VGND VGND VPWR VPWR sky130_fd_sc_hd__fill_2
X_853_ _330_ _331_ VGND VGND VPWR VPWR _332_ sky130_fd_sc_hd__or2_1
X_784_ _253_ _256_ VGND VGND VPWR VPWR _258_ sky130_fd_sc_hd__xnor2_1
X_922_ net68 _174_ _405_ _406_ VGND VGND VPWR VPWR _407_ sky130_fd_sc_hd__a211o_1
XFILLER_19_158 VGND VGND VPWR VPWR sky130_fd_sc_hd__decap_8
XFILLER_19_169 VGND VGND VPWR VPWR sky130_fd_sc_hd__decap_6
XFILLER_27_191 VPWR VGND VPWR VGND sky130_ef_sc_hd__decap_12
XFILLER_32_3 VGND VGND VPWR VPWR sky130_fd_sc_hd__fill_2
Xoutput28 net28 VGND VGND VPWR VPWR op_out[7] sky130_fd_sc_hd__buf_2
XFILLER_0_249 VGND VGND VPWR VPWR sky130_fd_sc_hd__decap_3
XFILLER_24_194 VGND VGND VPWR VPWR sky130_fd_sc_hd__fill_2
X_905_ net69 net60 VGND VGND VPWR VPWR _388_ sky130_fd_sc_hd__nand2_1
X_767_ net39 net57 _166_ _174_ net41 VGND VGND VPWR VPWR _240_ sky130_fd_sc_hd__a32o_1
X_836_ _161_ _312_ _313_ VGND VGND VPWR VPWR _314_ sky130_fd_sc_hd__and3b_1
X_698_ net66 net44 _167_ _168_ net42 VGND VGND VPWR VPWR _169_ sky130_fd_sc_hd__a32o_1
XFILLER_30_131 VGND VGND VPWR VPWR sky130_fd_sc_hd__fill_1
XFILLER_30_197 VPWR VGND VPWR VGND sky130_ef_sc_hd__decap_12
XFILLER_38_220 VGND VGND VPWR VPWR sky130_fd_sc_hd__fill_1
XFILLER_38_253 VGND VGND VPWR VPWR sky130_fd_sc_hd__decap_6
XFILLER_42_27 VGND VGND VPWR VPWR sky130_fd_sc_hd__fill_1
XFILLER_21_164 VGND VGND VPWR VPWR sky130_fd_sc_hd__decap_4
XTAP_TAPCELL_ROW_39_270 VGND VPWR sky130_fd_sc_hd__tapvpwrvgnd_1
XFILLER_29_242 VGND VGND VPWR VPWR sky130_fd_sc_hd__decap_3
X_621_ net58 _090_ VGND VGND VPWR VPWR _092_ sky130_fd_sc_hd__xnor2_1
XFILLER_12_153 VPWR VGND VPWR VGND sky130_ef_sc_hd__decap_12
XTAP_TAPCELL_ROW_14_159 VGND VPWR sky130_fd_sc_hd__tapvpwrvgnd_1
XFILLER_16_72 VGND VGND VPWR VPWR sky130_fd_sc_hd__decap_4
X_483_ net67 net34 _410_ VGND VGND VPWR VPWR _412_ sky130_fd_sc_hd__nand3_1
X_552_ _022_ VGND VGND VPWR VPWR _023_ sky130_fd_sc_hd__inv_2
XFILLER_12_197 VPWR VGND VPWR VGND sky130_ef_sc_hd__decap_12
XTAP_TAPCELL_ROW_22_192 VGND VPWR sky130_fd_sc_hd__tapvpwrvgnd_1
XFILLER_35_256 VGND VGND VPWR VPWR sky130_fd_sc_hd__decap_3
XFILLER_35_223 VGND VGND VPWR VPWR sky130_fd_sc_hd__fill_1
XFILLER_35_201 VGND VGND VPWR VPWR sky130_fd_sc_hd__decap_4
X_819_ _293_ _294_ VGND VGND VPWR VPWR _296_ sky130_fd_sc_hd__nor2_1
XFILLER_37_27 VPWR VGND VPWR VGND sky130_ef_sc_hd__decap_12
XTAP_TAPCELL_ROW_5_116 VGND VPWR sky130_fd_sc_hd__tapvpwrvgnd_1
XFILLER_26_212 VPWR VGND VPWR VGND sky130_ef_sc_hd__decap_12
XTAP_TAPCELL_ROW_28_218 VGND VPWR sky130_fd_sc_hd__tapvpwrvgnd_1
XFILLER_5_149 VPWR VGND VPWR VGND sky130_ef_sc_hd__decap_12
XFILLER_5_105 VGND VGND VPWR VPWR sky130_fd_sc_hd__decap_6
XFILLER_17_234 VPWR VGND VPWR VGND sky130_ef_sc_hd__decap_12
X_535_ net65 net38 VGND VGND VPWR VPWR _006_ sky130_fd_sc_hd__nor2_1
XFILLER_27_71 VPWR VGND VPWR VGND sky130_ef_sc_hd__decap_12
X_604_ net64 _072_ VGND VGND VPWR VPWR _075_ sky130_fd_sc_hd__xnor2_2
XFILLER_43_81 VGND VGND VPWR VPWR sky130_fd_sc_hd__decap_3
X_466_ net50 VGND VGND VPWR VPWR _273_ sky130_fd_sc_hd__inv_2
XTAP_TAPCELL_ROW_10_140 VGND VPWR sky130_fd_sc_hd__tapvpwrvgnd_1
XFILLER_4_97 VPWR VGND VPWR VGND sky130_ef_sc_hd__decap_12
XFILLER_4_53 VPWR VGND VPWR VGND sky130_ef_sc_hd__decap_12
XTAP_TAPCELL_ROW_33_243 VGND VPWR sky130_fd_sc_hd__tapvpwrvgnd_1
XFILLER_14_204 VGND VGND VPWR VPWR sky130_fd_sc_hd__fill_1
XFILLER_13_51 VGND VGND VPWR VPWR sky130_fd_sc_hd__decap_4
Xfanout41 net7 VGND VGND VPWR VPWR net41 sky130_fd_sc_hd__buf_2
Xfanout63 net64 VGND VGND VPWR VPWR net63 sky130_fd_sc_hd__buf_2
Xfanout52 net18 VGND VGND VPWR VPWR net52 sky130_fd_sc_hd__clkbuf_4
X_518_ net58 _446_ VGND VGND VPWR VPWR _447_ sky130_fd_sc_hd__nor2_1
XFILLER_18_29 VPWR VGND VPWR VGND sky130_ef_sc_hd__decap_12
XFILLER_10_251 VGND VGND VPWR VPWR sky130_fd_sc_hd__fill_1
XFILLER_6_233 VPWR VGND VPWR VGND sky130_ef_sc_hd__decap_12
XFILLER_24_50 VPWR VGND VPWR VGND sky130_ef_sc_hd__decap_12
XFILLER_37_159 VGND VGND VPWR VPWR sky130_fd_sc_hd__fill_1
XFILLER_27_6 VGND VGND VPWR VPWR sky130_fd_sc_hd__decap_8
XFILLER_10_85 VPWR VGND VPWR VGND sky130_ef_sc_hd__decap_12
XFILLER_10_41 VPWR VGND VPWR VGND sky130_ef_sc_hd__decap_12
XFILLER_3_225 VPWR VGND VPWR VGND sky130_ef_sc_hd__decap_12
X_921_ net12 net49 _166_ net33 _295_ VGND VGND VPWR VPWR _406_ sky130_fd_sc_hd__a32o_1
XFILLER_19_104 VGND VGND VPWR VPWR sky130_fd_sc_hd__fill_1
X_852_ net44 net51 _275_ _278_ VGND VGND VPWR VPWR _331_ sky130_fd_sc_hd__a211oi_1
X_783_ _253_ _256_ VGND VGND VPWR VPWR _257_ sky130_fd_sc_hd__nand2b_1
XFILLER_25_3 VGND VGND VPWR VPWR sky130_fd_sc_hd__decap_8
XFILLER_24_173 VPWR VGND VPWR VGND sky130_ef_sc_hd__decap_12
X_904_ _339_ _342_ _341_ VGND VGND VPWR VPWR _387_ sky130_fd_sc_hd__o21bai_1
X_697_ net2 net47 net3 net1 VGND VGND VPWR VPWR _168_ sky130_fd_sc_hd__and4bb_2
X_766_ net39 net57 _157_ _238_ VGND VGND VPWR VPWR _239_ sky130_fd_sc_hd__o22a_1
X_835_ _305_ _311_ VGND VGND VPWR VPWR _313_ sky130_fd_sc_hd__or2_1
XFILLER_30_121 VGND VGND VPWR VPWR sky130_fd_sc_hd__decap_4
XPHY_EDGE_ROW_15_Left_59 VGND VGND VPWR VPWR sky130_fd_sc_hd__decap_3
XPHY_EDGE_ROW_5_Right_5 VGND VGND VPWR VPWR sky130_fd_sc_hd__decap_3
XFILLER_21_110 VGND VGND VPWR VPWR sky130_fd_sc_hd__fill_2
XFILLER_26_29 VPWR VGND VPWR VGND sky130_ef_sc_hd__decap_12
XTAP_TAPCELL_ROW_39_271 VGND VPWR sky130_fd_sc_hd__tapvpwrvgnd_1
X_551_ _020_ _021_ VGND VGND VPWR VPWR _022_ sky130_fd_sc_hd__nand2_1
XFILLER_29_254 VGND VGND VPWR VPWR sky130_fd_sc_hd__fill_1
X_620_ _252_ _090_ VGND VGND VPWR VPWR _091_ sky130_fd_sc_hd__xnor2_1
XFILLER_12_121 VPWR VGND VPWR VGND sky130_ef_sc_hd__decap_12
XFILLER_12_165 VPWR VGND VPWR VGND sky130_ef_sc_hd__decap_12
X_482_ net67 net34 _410_ VGND VGND VPWR VPWR _411_ sky130_fd_sc_hd__and3_1
XTAP_TAPCELL_ROW_22_193 VGND VPWR sky130_fd_sc_hd__tapvpwrvgnd_1
XFILLER_32_50 VGND VGND VPWR VPWR sky130_fd_sc_hd__fill_2
XFILLER_32_83 VGND VGND VPWR VPWR sky130_fd_sc_hd__fill_1
X_818_ _257_ _259_ _292_ VGND VGND VPWR VPWR _294_ sky130_fd_sc_hd__a21oi_1
X_749_ _161_ _218_ _219_ VGND VGND VPWR VPWR _221_ sky130_fd_sc_hd__or3b_1
XTAP_TAPCELL_ROW_5_117 VGND VPWR sky130_fd_sc_hd__tapvpwrvgnd_1
XFILLER_37_39 VGND VGND VPWR VPWR sky130_fd_sc_hd__decap_8
XFILLER_26_224 VPWR VGND VPWR VGND sky130_ef_sc_hd__decap_12
XTAP_TAPCELL_ROW_28_219 VGND VPWR sky130_fd_sc_hd__tapvpwrvgnd_1
XFILLER_41_205 VGND VGND VPWR VPWR sky130_fd_sc_hd__fill_1
X_534_ _003_ _004_ VGND VGND VPWR VPWR _005_ sky130_fd_sc_hd__and2b_1
XFILLER_17_246 VGND VGND VPWR VPWR sky130_fd_sc_hd__decap_8
X_465_ net59 VGND VGND VPWR VPWR _263_ sky130_fd_sc_hd__inv_2
XFILLER_27_83 VPWR VGND VPWR VGND sky130_ef_sc_hd__decap_12
X_603_ net34 _072_ VGND VGND VPWR VPWR _074_ sky130_fd_sc_hd__and2_1
XTAP_TAPCELL_ROW_10_141 VGND VPWR sky130_fd_sc_hd__tapvpwrvgnd_1
XFILLER_4_65 VPWR VGND VPWR VGND sky130_ef_sc_hd__decap_12
XFILLER_23_205 VGND VGND VPWR VPWR sky130_fd_sc_hd__decap_8
XTAP_TAPCELL_ROW_33_244 VGND VPWR sky130_fd_sc_hd__tapvpwrvgnd_1
XFILLER_2_109 VPWR VGND VPWR VGND sky130_ef_sc_hd__decap_12
XPHY_EDGE_ROW_18_Left_62 VGND VGND VPWR VPWR sky130_fd_sc_hd__decap_3
XTAP_TAPCELL_ROW_24_200 VGND VPWR sky130_fd_sc_hd__tapvpwrvgnd_1
Xfanout53 net18 VGND VGND VPWR VPWR net53 sky130_fd_sc_hd__buf_2
Xfanout42 net43 VGND VGND VPWR VPWR net42 sky130_fd_sc_hd__buf_2
Xfanout64 net14 VGND VGND VPWR VPWR net64 sky130_fd_sc_hd__clkbuf_4
XFILLER_38_82 VGND VGND VPWR VPWR sky130_fd_sc_hd__fill_2
XTAP_TAPCELL_ROW_0_88 VGND VPWR sky130_fd_sc_hd__tapvpwrvgnd_1
X_517_ _427_ _445_ _444_ VGND VGND VPWR VPWR _446_ sky130_fd_sc_hd__mux2_1
XFILLER_34_18 VGND VGND VPWR VPWR sky130_fd_sc_hd__decap_8
XFILLER_34_29 VGND VGND VPWR VPWR sky130_fd_sc_hd__decap_8
XPHY_EDGE_ROW_3_Left_47 VGND VGND VPWR VPWR sky130_fd_sc_hd__decap_3
XFILLER_6_245 VGND VGND VPWR VPWR sky130_fd_sc_hd__decap_6
XFILLER_24_62 VGND VGND VPWR VPWR sky130_fd_sc_hd__decap_6
XFILLER_40_94 VGND VGND VPWR VPWR sky130_fd_sc_hd__fill_1
XFILLER_40_83 VGND VGND VPWR VPWR sky130_fd_sc_hd__fill_1
XFILLER_1_55 VGND VGND VPWR VPWR sky130_fd_sc_hd__fill_1
XFILLER_43_119 VGND VGND VPWR VPWR sky130_fd_sc_hd__decap_3
XFILLER_10_97 VPWR VGND VPWR VGND sky130_ef_sc_hd__decap_12
XFILLER_10_53 VPWR VGND VPWR VGND sky130_ef_sc_hd__decap_12
XFILLER_3_237 VPWR VGND VPWR VGND sky130_ef_sc_hd__decap_12
X_851_ _275_ _278_ net44 net50 VGND VGND VPWR VPWR _330_ sky130_fd_sc_hd__o211a_1
X_920_ net12 net49 _157_ _404_ VGND VGND VPWR VPWR _405_ sky130_fd_sc_hd__o22a_1
XFILLER_19_51 VGND VGND VPWR VPWR sky130_fd_sc_hd__decap_4
XFILLER_19_116 VGND VGND VPWR VPWR sky130_fd_sc_hd__decap_6
X_782_ _206_ _255_ VGND VGND VPWR VPWR _256_ sky130_fd_sc_hd__xnor2_1
XFILLER_42_141 VPWR VGND VPWR VGND sky130_ef_sc_hd__decap_12
XFILLER_42_130 VGND VGND VPWR VPWR sky130_fd_sc_hd__decap_3
XFILLER_18_3 VPWR VGND VPWR VGND sky130_ef_sc_hd__decap_12
XFILLER_33_141 VPWR VGND VPWR VGND sky130_ef_sc_hd__decap_12
XFILLER_33_185 VPWR VGND VPWR VGND sky130_ef_sc_hd__decap_12
XFILLER_24_141 VPWR VGND VPWR VGND sky130_ef_sc_hd__decap_12
XFILLER_24_185 VGND VGND VPWR VPWR sky130_fd_sc_hd__decap_4
X_903_ _377_ _385_ VGND VGND VPWR VPWR _386_ sky130_fd_sc_hd__xnor2_1
X_834_ _305_ _311_ VGND VGND VPWR VPWR _312_ sky130_fd_sc_hd__nand2_1
X_696_ net32 _166_ VGND VGND VPWR VPWR _167_ sky130_fd_sc_hd__or2_1
X_765_ net39 net57 _159_ VGND VGND VPWR VPWR _238_ sky130_fd_sc_hd__a21oi_1
XPHY_EDGE_ROW_6_Left_50 VGND VGND VPWR VPWR sky130_fd_sc_hd__decap_3
XTAP_TAPCELL_ROW_17_169 VGND VPWR sky130_fd_sc_hd__tapvpwrvgnd_1
XFILLER_30_155 VGND VGND VPWR VPWR sky130_fd_sc_hd__fill_2
XFILLER_42_29 VPWR VGND VPWR VGND sky130_ef_sc_hd__decap_12
XFILLER_16_41 VPWR VGND VPWR VGND sky130_ef_sc_hd__decap_12
X_550_ _015_ net31 _210_ VGND VGND VPWR VPWR _021_ sky130_fd_sc_hd__a21o_1
X_481_ _381_ _338_ _360_ net35 VGND VGND VPWR VPWR _410_ sky130_fd_sc_hd__a211o_1
XFILLER_29_222 VGND VGND VPWR VPWR sky130_fd_sc_hd__fill_2
XPHY_EDGE_ROW_11_Right_11 VGND VGND VPWR VPWR sky130_fd_sc_hd__decap_3
XFILLER_12_133 VGND VGND VPWR VPWR sky130_fd_sc_hd__decap_6
XFILLER_12_177 VPWR VGND VPWR VGND sky130_ef_sc_hd__decap_12
XFILLER_16_85 VGND VGND VPWR VPWR sky130_fd_sc_hd__decap_8
XTAP_TAPCELL_ROW_22_194 VGND VPWR sky130_fd_sc_hd__tapvpwrvgnd_1
XPHY_EDGE_ROW_32_Left_76 VGND VGND VPWR VPWR sky130_fd_sc_hd__decap_3
XFILLER_32_73 VGND VGND VPWR VPWR sky130_fd_sc_hd__fill_1
XPHY_EDGE_ROW_20_Right_20 VGND VGND VPWR VPWR sky130_fd_sc_hd__decap_3
X_817_ _257_ _259_ _292_ VGND VGND VPWR VPWR _293_ sky130_fd_sc_hd__and3_1
X_748_ _192_ _194_ _217_ VGND VGND VPWR VPWR _219_ sky130_fd_sc_hd__a21o_1
X_679_ _146_ _149_ _295_ VGND VGND VPWR VPWR _150_ sky130_fd_sc_hd__o21a_1
XFILLER_35_225 VGND VGND VPWR VPWR sky130_fd_sc_hd__decap_4
XFILLER_7_181 VPWR VGND VPWR VGND sky130_ef_sc_hd__decap_12
XTAP_TAPCELL_ROW_5_118 VGND VPWR sky130_fd_sc_hd__tapvpwrvgnd_1
XFILLER_26_236 VGND VGND VPWR VPWR sky130_fd_sc_hd__decap_4
X_602_ _072_ VGND VGND VPWR VPWR _073_ sky130_fd_sc_hd__inv_2
XFILLER_17_225 VGND VGND VPWR VPWR sky130_fd_sc_hd__fill_2
X_533_ _220_ _444_ _001_ net62 VGND VGND VPWR VPWR _004_ sky130_fd_sc_hd__o211ai_2
X_464_ net58 VGND VGND VPWR VPWR _252_ sky130_fd_sc_hd__inv_2
XFILLER_27_51 VGND VGND VPWR VPWR sky130_fd_sc_hd__decap_4
XFILLER_27_95 VGND VGND VPWR VPWR sky130_fd_sc_hd__decap_6
XFILLER_4_195 VGND VGND VPWR VPWR sky130_fd_sc_hd__fill_1
XFILLER_4_77 VGND VGND VPWR VPWR sky130_fd_sc_hd__decap_6
XTAP_TAPCELL_ROW_24_201 VGND VPWR sky130_fd_sc_hd__tapvpwrvgnd_1
Xfanout65 net66 VGND VGND VPWR VPWR net65 sky130_fd_sc_hd__buf_2
Xfanout43 net6 VGND VGND VPWR VPWR net43 sky130_fd_sc_hd__clkbuf_4
Xfanout54 net17 VGND VGND VPWR VPWR net54 sky130_fd_sc_hd__buf_2
XTAP_TAPCELL_ROW_0_89 VGND VPWR sky130_fd_sc_hd__tapvpwrvgnd_1
XFILLER_38_50 VGND VGND VPWR VPWR sky130_fd_sc_hd__decap_3
X_516_ _430_ _437_ VGND VGND VPWR VPWR _445_ sky130_fd_sc_hd__xnor2_1
XFILLER_24_85 VPWR VGND VPWR VGND sky130_ef_sc_hd__decap_12
XFILLER_10_253 VGND VGND VPWR VPWR sky130_fd_sc_hd__decap_6
XFILLER_28_139 VGND VGND VPWR VPWR sky130_fd_sc_hd__fill_1
XFILLER_43_109 VGND VGND VPWR VPWR sky130_fd_sc_hd__decap_3
XFILLER_3_205 VPWR VGND VPWR VGND sky130_ef_sc_hd__decap_12
XFILLER_10_65 VPWR VGND VPWR VGND sky130_ef_sc_hd__decap_12
XFILLER_3_249 VGND VGND VPWR VPWR sky130_fd_sc_hd__decap_8
X_781_ _455_ _224_ _254_ VGND VGND VPWR VPWR _255_ sky130_fd_sc_hd__a21oi_2
X_850_ _249_ _296_ _294_ VGND VGND VPWR VPWR _329_ sky130_fd_sc_hd__a21o_1
XFILLER_42_153 VGND VGND VPWR VPWR sky130_fd_sc_hd__decap_4
XFILLER_18_194 VGND VGND VPWR VPWR sky130_fd_sc_hd__fill_2
XFILLER_33_153 VPWR VGND VPWR VGND sky130_ef_sc_hd__decap_12
XFILLER_33_197 VGND VGND VPWR VPWR sky130_fd_sc_hd__decap_4
X_764_ _203_ _234_ _165_ VGND VGND VPWR VPWR _237_ sky130_fd_sc_hd__o21a_1
X_902_ _383_ _384_ VGND VGND VPWR VPWR _385_ sky130_fd_sc_hd__and2b_1
X_833_ _309_ _310_ VGND VGND VPWR VPWR _311_ sky130_fd_sc_hd__and2_1
X_695_ net2 _199_ net47 net1 VGND VGND VPWR VPWR _166_ sky130_fd_sc_hd__and4b_2
XFILLER_15_153 VGND VGND VPWR VPWR sky130_fd_sc_hd__decap_3
XFILLER_7_55 VGND VGND VPWR VPWR sky130_fd_sc_hd__fill_1
XFILLER_30_3 VGND VGND VPWR VPWR sky130_fd_sc_hd__decap_4
XFILLER_38_234 VGND VGND VPWR VPWR sky130_fd_sc_hd__fill_1
XFILLER_16_53 VPWR VGND VPWR VGND sky130_ef_sc_hd__decap_12
X_480_ net70 _381_ _360_ VGND VGND VPWR VPWR _409_ sky130_fd_sc_hd__a21oi_1
XFILLER_12_189 VGND VGND VPWR VPWR sky130_fd_sc_hd__decap_6
XTAP_TAPCELL_ROW_22_195 VGND VPWR sky130_fd_sc_hd__tapvpwrvgnd_1
X_747_ _192_ _194_ _217_ VGND VGND VPWR VPWR _218_ sky130_fd_sc_hd__and3_1
X_816_ _290_ _291_ VGND VGND VPWR VPWR _292_ sky130_fd_sc_hd__nand2_1
X_678_ _109_ _119_ _133_ _148_ VGND VGND VPWR VPWR _149_ sky130_fd_sc_hd__nor4_1
XFILLER_35_248 VGND VGND VPWR VPWR sky130_fd_sc_hd__decap_8
XTAP_TAPCELL_ROW_13_151 VGND VPWR sky130_fd_sc_hd__tapvpwrvgnd_1
XFILLER_7_193 VPWR VGND VPWR VGND sky130_ef_sc_hd__decap_12
XTAP_TAPCELL_ROW_36_254 VGND VPWR sky130_fd_sc_hd__tapvpwrvgnd_1
XFILLER_26_248 VGND VGND VPWR VPWR sky130_fd_sc_hd__decap_4
XFILLER_17_215 VGND VGND VPWR VPWR sky130_fd_sc_hd__fill_1
XFILLER_27_41 VGND VGND VPWR VPWR sky130_fd_sc_hd__fill_1
X_601_ net41 _071_ net30 VGND VGND VPWR VPWR _072_ sky130_fd_sc_hd__mux2_2
X_532_ net36 _444_ _000_ net34 VGND VGND VPWR VPWR _003_ sky130_fd_sc_hd__o211a_1
X_463_ net62 VGND VGND VPWR VPWR _242_ sky130_fd_sc_hd__inv_2
XFILLER_4_141 VPWR VGND VPWR VGND sky130_ef_sc_hd__decap_12
XTAP_TAPCELL_ROW_1_100 VGND VPWR sky130_fd_sc_hd__tapvpwrvgnd_1
Xfanout55 net17 VGND VGND VPWR VPWR net55 sky130_fd_sc_hd__buf_2
XTAP_TAPCELL_ROW_24_202 VGND VPWR sky130_fd_sc_hd__tapvpwrvgnd_1
Xfanout44 net46 VGND VGND VPWR VPWR net44 sky130_fd_sc_hd__buf_2
Xfanout66 net13 VGND VGND VPWR VPWR net66 sky130_fd_sc_hd__buf_2
XFILLER_8_3 VPWR VGND VPWR VGND sky130_ef_sc_hd__decap_12
XFILLER_1_111 VGND VGND VPWR VPWR sky130_fd_sc_hd__fill_1
XFILLER_38_62 VPWR VGND VPWR VGND sky130_ef_sc_hd__decap_12
X_515_ _442_ _438_ _443_ VGND VGND VPWR VPWR _444_ sky130_fd_sc_hd__a21oi_4
XTAP_TAPCELL_ROW_30_227 VGND VPWR sky130_fd_sc_hd__tapvpwrvgnd_1
XFILLER_10_221 VPWR VGND VPWR VGND sky130_ef_sc_hd__decap_12
XFILLER_24_97 VGND VGND VPWR VPWR sky130_fd_sc_hd__fill_1
XFILLER_40_41 VPWR VGND VPWR VGND sky130_ef_sc_hd__decap_12
XFILLER_1_57 VPWR VGND VPWR VGND sky130_ef_sc_hd__decap_12
Xinput1 inst[0] VGND VGND VPWR VPWR net1 sky130_fd_sc_hd__dlymetal6s2s_1
XFILLER_36_162 VGND VGND VPWR VPWR sky130_fd_sc_hd__fill_1
XFILLER_3_217 VGND VGND VPWR VPWR sky130_fd_sc_hd__decap_6
XFILLER_10_77 VGND VGND VPWR VPWR sky130_fd_sc_hd__decap_6
X_780_ net36 net63 _007_ VGND VGND VPWR VPWR _254_ sky130_fd_sc_hd__and3_1
XFILLER_33_165 VGND VGND VPWR VPWR sky130_fd_sc_hd__decap_3
XFILLER_0_209 VPWR VGND VPWR VGND sky130_ef_sc_hd__decap_12
X_901_ _378_ _379_ _380_ _382_ VGND VGND VPWR VPWR _384_ sky130_fd_sc_hd__a22o_1
X_694_ net3 net47 _158_ VGND VGND VPWR VPWR _165_ sky130_fd_sc_hd__nor3_1
X_763_ _203_ _234_ VGND VGND VPWR VPWR _236_ sky130_fd_sc_hd__nand2_1
Xmax_cap30 _061_ VGND VGND VPWR VPWR net30 sky130_fd_sc_hd__buf_6
X_832_ net69 _308_ VGND VGND VPWR VPWR _310_ sky130_fd_sc_hd__nand2_1
XFILLER_15_132 VGND VGND VPWR VPWR sky130_fd_sc_hd__decap_8
XFILLER_15_176 VGND VGND VPWR VPWR sky130_fd_sc_hd__decap_4
XFILLER_23_3 VGND VGND VPWR VPWR sky130_fd_sc_hd__fill_2
XFILLER_21_102 VGND VGND VPWR VPWR sky130_fd_sc_hd__decap_8
XTAP_TAPCELL_ROW_8_128 VGND VPWR sky130_fd_sc_hd__tapvpwrvgnd_1
XFILLER_16_76 VGND VGND VPWR VPWR sky130_fd_sc_hd__fill_1
XFILLER_8_139 VGND VGND VPWR VPWR sky130_fd_sc_hd__fill_1
X_746_ _215_ _216_ VGND VGND VPWR VPWR _217_ sky130_fd_sc_hd__nand2_1
X_815_ _279_ _289_ VGND VGND VPWR VPWR _291_ sky130_fd_sc_hd__nand2_1
X_677_ _242_ _136_ _137_ _138_ _147_ VGND VGND VPWR VPWR _148_ sky130_fd_sc_hd__a2111o_1
XTAP_TAPCELL_ROW_13_152 VGND VPWR sky130_fd_sc_hd__tapvpwrvgnd_1
XPHY_EDGE_ROW_9_Right_9 VGND VGND VPWR VPWR sky130_fd_sc_hd__decap_3
XFILLER_7_161 VGND VGND VPWR VPWR sky130_fd_sc_hd__decap_6
XTAP_TAPCELL_ROW_36_255 VGND VPWR sky130_fd_sc_hd__tapvpwrvgnd_1
X_531_ net36 _444_ _000_ VGND VGND VPWR VPWR _002_ sky130_fd_sc_hd__o21ai_1
X_600_ _029_ _070_ VGND VGND VPWR VPWR _071_ sky130_fd_sc_hd__nand2_1
XFILLER_43_85 VPWR VGND VPWR VGND sky130_ef_sc_hd__decap_12
XFILLER_43_41 VPWR VGND VPWR VGND sky130_ef_sc_hd__decap_12
XFILLER_40_241 VGND VGND VPWR VPWR sky130_fd_sc_hd__decap_3
X_462_ net12 VGND VGND VPWR VPWR _231_ sky130_fd_sc_hd__inv_2
XFILLER_4_153 VPWR VGND VPWR VGND sky130_ef_sc_hd__decap_12
XFILLER_4_197 VPWR VGND VPWR VGND sky130_ef_sc_hd__decap_12
X_729_ net45 net60 _197_ _198_ VGND VGND VPWR VPWR _200_ sky130_fd_sc_hd__o2bb2a_1
XTAP_TAPCELL_ROW_41_280 VGND VPWR sky130_fd_sc_hd__tapvpwrvgnd_1
Xfanout45 net46 VGND VGND VPWR VPWR net45 sky130_fd_sc_hd__buf_1
Xfanout67 net11 VGND VGND VPWR VPWR net67 sky130_fd_sc_hd__buf_2
XTAP_TAPCELL_ROW_24_203 VGND VPWR sky130_fd_sc_hd__tapvpwrvgnd_1
Xfanout56 net58 VGND VGND VPWR VPWR net56 sky130_fd_sc_hd__buf_2
Xfanout34 _242_ VGND VGND VPWR VPWR net34 sky130_fd_sc_hd__buf_2
XFILLER_13_55 VGND VGND VPWR VPWR sky130_fd_sc_hd__fill_1
XFILLER_1_167 VGND VGND VPWR VPWR sky130_fd_sc_hd__fill_1
XFILLER_38_85 VPWR VGND VPWR VGND sky130_ef_sc_hd__decap_12
XFILLER_38_74 VGND VGND VPWR VPWR sky130_fd_sc_hd__decap_8
X_514_ net56 _338_ _306_ VGND VGND VPWR VPWR _443_ sky130_fd_sc_hd__a21o_1
XFILLER_9_223 VGND VGND VPWR VPWR sky130_fd_sc_hd__fill_1
XFILLER_13_241 VPWR VGND VPWR VGND sky130_ef_sc_hd__decap_12
XTAP_TAPCELL_ROW_30_228 VGND VPWR sky130_fd_sc_hd__tapvpwrvgnd_1
XFILLER_10_233 VPWR VGND VPWR VGND sky130_ef_sc_hd__decap_12
XFILLER_40_53 VPWR VGND VPWR VGND sky130_ef_sc_hd__decap_12
XFILLER_1_69 VPWR VGND VPWR VGND sky130_ef_sc_hd__decap_12
Xinput2 inst[1] VGND VGND VPWR VPWR net2 sky130_fd_sc_hd__buf_1
XFILLER_36_141 VGND VGND VPWR VPWR sky130_fd_sc_hd__decap_8
XFILLER_36_130 VGND VGND VPWR VPWR sky130_fd_sc_hd__decap_8
XFILLER_19_98 VGND VGND VPWR VPWR sky130_fd_sc_hd__decap_6
XFILLER_27_152 VPWR VGND VPWR VGND sky130_ef_sc_hd__decap_12
XFILLER_27_174 VGND VGND VPWR VPWR sky130_fd_sc_hd__fill_2
XFILLER_35_97 VGND VGND VPWR VPWR sky130_fd_sc_hd__fill_2
XFILLER_2_251 VGND VGND VPWR VPWR sky130_fd_sc_hd__fill_1
XFILLER_18_141 VPWR VGND VPWR VGND sky130_ef_sc_hd__decap_12
XFILLER_33_111 VGND VGND VPWR VPWR sky130_fd_sc_hd__fill_1
XFILLER_33_133 VGND VGND VPWR VPWR sky130_fd_sc_hd__decap_3
XTAP_TAPCELL_ROW_19_180 VGND VPWR sky130_fd_sc_hd__tapvpwrvgnd_1
XFILLER_21_55 VGND VGND VPWR VPWR sky130_fd_sc_hd__fill_1
X_900_ _378_ _379_ _380_ _382_ VGND VGND VPWR VPWR _383_ sky130_fd_sc_hd__and4_1
X_831_ net69 _308_ VGND VGND VPWR VPWR _309_ sky130_fd_sc_hd__or2_1
X_693_ _199_ net47 _158_ VGND VGND VPWR VPWR _164_ sky130_fd_sc_hd__nor3_1
X_762_ _203_ _234_ VGND VGND VPWR VPWR _235_ sky130_fd_sc_hd__and2_1
Xmax_cap31 _017_ VGND VGND VPWR VPWR net31 sky130_fd_sc_hd__buf_1
XFILLER_15_166 VGND VGND VPWR VPWR sky130_fd_sc_hd__fill_2
XFILLER_7_57 VPWR VGND VPWR VGND sky130_ef_sc_hd__decap_12
XFILLER_16_3 VPWR VGND VPWR VGND sky130_ef_sc_hd__decap_12
XTAP_TAPCELL_ROW_8_129 VGND VPWR sky130_fd_sc_hd__tapvpwrvgnd_1
X_814_ _279_ _289_ VGND VGND VPWR VPWR _290_ sky130_fd_sc_hd__or2_1
X_745_ net39 _214_ VGND VGND VPWR VPWR _216_ sky130_fd_sc_hd__nand2_1
XFILLER_35_217 VGND VGND VPWR VPWR sky130_fd_sc_hd__decap_6
X_676_ _188_ net46 VGND VGND VPWR VPWR _147_ sky130_fd_sc_hd__nor2_1
XTAP_TAPCELL_ROW_13_153 VGND VPWR sky130_fd_sc_hd__tapvpwrvgnd_1
XTAP_TAPCELL_ROW_36_256 VGND VPWR sky130_fd_sc_hd__tapvpwrvgnd_1
XTAP_TAPCELL_ROW_4_110 VGND VPWR sky130_fd_sc_hd__tapvpwrvgnd_1
X_530_ _438_ _442_ _443_ _457_ VGND VGND VPWR VPWR _001_ sky130_fd_sc_hd__a211o_1
X_461_ net36 VGND VGND VPWR VPWR _220_ sky130_fd_sc_hd__inv_2
XFILLER_32_209 VPWR VGND VPWR VGND sky130_ef_sc_hd__decap_12
XFILLER_43_97 VPWR VGND VPWR VGND sky130_ef_sc_hd__decap_12
XFILLER_43_53 VGND VGND VPWR VPWR sky130_fd_sc_hd__decap_3
XFILLER_4_165 VPWR VGND VPWR VGND sky130_ef_sc_hd__decap_12
XFILLER_4_121 VPWR VGND VPWR VGND sky130_ef_sc_hd__decap_12
X_728_ net13 net7 _171_ VGND VGND VPWR VPWR _198_ sky130_fd_sc_hd__and3_1
X_659_ net29 _127_ _129_ _252_ VGND VGND VPWR VPWR _130_ sky130_fd_sc_hd__a211o_1
Xfanout57 net58 VGND VGND VPWR VPWR net57 sky130_fd_sc_hd__dlymetal6s2s_1
Xfanout68 net11 VGND VGND VPWR VPWR net68 sky130_fd_sc_hd__clkbuf_2
XFILLER_22_253 VGND VGND VPWR VPWR sky130_fd_sc_hd__decap_6
Xfanout46 net5 VGND VGND VPWR VPWR net46 sky130_fd_sc_hd__buf_2
XTAP_TAPCELL_ROW_24_204 VGND VPWR sky130_fd_sc_hd__tapvpwrvgnd_1
Xfanout35 _188_ VGND VGND VPWR VPWR net35 sky130_fd_sc_hd__clkbuf_4
XFILLER_1_113 VPWR VGND VPWR VGND sky130_ef_sc_hd__decap_12
XFILLER_38_97 VGND VGND VPWR VPWR sky130_fd_sc_hd__decap_8
X_513_ net58 _441_ _428_ VGND VGND VPWR VPWR _442_ sky130_fd_sc_hd__o21ba_1
XFILLER_9_257 VGND VGND VPWR VPWR sky130_fd_sc_hd__fill_2
XFILLER_13_253 VGND VGND VPWR VPWR sky130_fd_sc_hd__decap_6
XTAP_TAPCELL_ROW_30_229 VGND VPWR sky130_fd_sc_hd__tapvpwrvgnd_1
XFILLER_39_194 VPWR VGND VPWR VGND sky130_ef_sc_hd__decap_12
XFILLER_10_245 VGND VGND VPWR VPWR sky130_fd_sc_hd__decap_6
XFILLER_40_65 VPWR VGND VPWR VGND sky130_ef_sc_hd__decap_12
XPHY_EDGE_ROW_39_Left_83 VGND VGND VPWR VPWR sky130_fd_sc_hd__decap_3
XFILLER_1_15 VPWR VGND VPWR VGND sky130_ef_sc_hd__decap_12
XPHY_EDGE_ROW_23_Left_67 VGND VGND VPWR VPWR sky130_fd_sc_hd__decap_3
XPHY_EDGE_ROW_18_Right_18 VGND VGND VPWR VPWR sky130_fd_sc_hd__decap_3
XFILLER_28_109 VPWR VGND VPWR VGND sky130_ef_sc_hd__decap_12
Xinput3 inst[2] VGND VGND VPWR VPWR net3 sky130_fd_sc_hd__clkbuf_2
XFILLER_36_197 VPWR VGND VPWR VGND sky130_ef_sc_hd__decap_12
XPHY_EDGE_ROW_27_Right_27 VGND VGND VPWR VPWR sky130_fd_sc_hd__decap_3
XPHY_EDGE_ROW_36_Right_36 VGND VGND VPWR VPWR sky130_fd_sc_hd__decap_3
XFILLER_19_55 VGND VGND VPWR VPWR sky130_fd_sc_hd__fill_1
XFILLER_19_109 VGND VGND VPWR VPWR sky130_fd_sc_hd__decap_3
XFILLER_42_178 VGND VGND VPWR VPWR sky130_fd_sc_hd__decap_8
XFILLER_27_164 VGND VGND VPWR VPWR sky130_fd_sc_hd__decap_4
XFILLER_35_32 VGND VGND VPWR VPWR sky130_fd_sc_hd__fill_1
XFILLER_35_76 VGND VGND VPWR VPWR sky130_fd_sc_hd__decap_8
XFILLER_18_153 VPWR VGND VPWR VGND sky130_ef_sc_hd__decap_12
XFILLER_18_186 VGND VGND VPWR VPWR sky130_fd_sc_hd__decap_8
XTAP_TAPCELL_ROW_19_181 VGND VPWR sky130_fd_sc_hd__tapvpwrvgnd_1
XFILLER_24_112 VPWR VGND VPWR VGND sky130_ef_sc_hd__decap_12
XFILLER_21_78 VPWR VGND VPWR VGND sky130_ef_sc_hd__decap_12
X_761_ _232_ _233_ VGND VGND VPWR VPWR _234_ sky130_fd_sc_hd__nor2_1
X_830_ net53 _307_ VGND VGND VPWR VPWR _308_ sky130_fd_sc_hd__xnor2_1
Xmax_cap32 _165_ VGND VGND VPWR VPWR net32 sky130_fd_sc_hd__clkbuf_2
X_692_ net66 net44 _157_ _162_ VGND VGND VPWR VPWR _163_ sky130_fd_sc_hd__o22a_1
XFILLER_7_69 VPWR VGND VPWR VGND sky130_ef_sc_hd__decap_12
XPHY_EDGE_ROW_26_Left_70 VGND VGND VPWR VPWR sky130_fd_sc_hd__decap_3
XPHY_EDGE_ROW_10_Left_54 VGND VGND VPWR VPWR sky130_fd_sc_hd__decap_3
XFILLER_29_248 VGND VGND VPWR VPWR sky130_fd_sc_hd__decap_6
XPHY_EDGE_ROW_0_Right_0 VGND VGND VPWR VPWR sky130_fd_sc_hd__decap_3
XFILLER_20_170 VGND VGND VPWR VPWR sky130_fd_sc_hd__fill_1
XFILLER_32_77 VGND VGND VPWR VPWR sky130_fd_sc_hd__decap_6
X_744_ net38 _214_ VGND VGND VPWR VPWR _215_ sky130_fd_sc_hd__or2_1
X_813_ _280_ _287_ VGND VGND VPWR VPWR _289_ sky130_fd_sc_hd__xnor2_1
X_675_ _109_ _143_ _145_ VGND VGND VPWR VPWR _146_ sky130_fd_sc_hd__o21a_1
XFILLER_11_181 VPWR VGND VPWR VGND sky130_ef_sc_hd__decap_12
XTAP_TAPCELL_ROW_13_154 VGND VPWR sky130_fd_sc_hd__tapvpwrvgnd_1
XTAP_TAPCELL_ROW_36_257 VGND VPWR sky130_fd_sc_hd__tapvpwrvgnd_1
XFILLER_34_251 VGND VGND VPWR VPWR sky130_fd_sc_hd__fill_1
XTAP_TAPCELL_ROW_4_111 VGND VPWR sky130_fd_sc_hd__tapvpwrvgnd_1
XFILLER_17_207 VGND VGND VPWR VPWR sky130_fd_sc_hd__decap_8
X_460_ net38 VGND VGND VPWR VPWR _210_ sky130_fd_sc_hd__inv_2
XFILLER_27_55 VGND VGND VPWR VPWR sky130_fd_sc_hd__fill_1
XFILLER_4_177 VPWR VGND VPWR VGND sky130_ef_sc_hd__decap_12
XFILLER_4_133 VGND VGND VPWR VPWR sky130_fd_sc_hd__decap_6
XFILLER_4_15 VPWR VGND VPWR VGND sky130_ef_sc_hd__decap_12
X_727_ _196_ VGND VGND VPWR VPWR _197_ sky130_fd_sc_hd__inv_2
XFILLER_16_251 VGND VGND VPWR VPWR sky130_fd_sc_hd__fill_1
X_589_ _034_ _038_ _037_ VGND VGND VPWR VPWR _060_ sky130_fd_sc_hd__a21o_1
X_658_ _066_ _099_ VGND VGND VPWR VPWR _129_ sky130_fd_sc_hd__nor2_1
Xfanout47 net4 VGND VGND VPWR VPWR net47 sky130_fd_sc_hd__clkbuf_2
XFILLER_13_57 VPWR VGND VPWR VGND sky130_ef_sc_hd__decap_12
Xfanout69 net10 VGND VGND VPWR VPWR net69 sky130_fd_sc_hd__buf_2
Xfanout36 net37 VGND VGND VPWR VPWR net36 sky130_fd_sc_hd__buf_2
Xfanout58 net16 VGND VGND VPWR VPWR net58 sky130_fd_sc_hd__clkbuf_4
XFILLER_1_125 VPWR VGND VPWR VGND sky130_ef_sc_hd__decap_12
XFILLER_1_169 VPWR VGND VPWR VGND sky130_ef_sc_hd__decap_12
XFILLER_9_225 VPWR VGND VPWR VGND sky130_ef_sc_hd__decap_12
X_512_ _439_ _440_ VGND VGND VPWR VPWR _441_ sky130_fd_sc_hd__and2_1
XFILLER_39_162 VGND VGND VPWR VPWR sky130_fd_sc_hd__decap_6
XFILLER_40_77 VGND VGND VPWR VPWR sky130_fd_sc_hd__decap_6
XFILLER_40_88 VGND VGND VPWR VPWR sky130_fd_sc_hd__decap_6
XFILLER_6_3 VPWR VGND VPWR VGND sky130_ef_sc_hd__decap_12
XFILLER_1_27 VPWR VGND VPWR VGND sky130_ef_sc_hd__decap_12
Xinput4 inst[3] VGND VGND VPWR VPWR net4 sky130_fd_sc_hd__clkbuf_1
XFILLER_39_3 VPWR VGND VPWR VGND sky130_ef_sc_hd__decap_12
XPHY_EDGE_ROW_40_Left_84 VGND VGND VPWR VPWR sky130_fd_sc_hd__decap_3
XFILLER_27_110 VGND VGND VPWR VPWR sky130_fd_sc_hd__fill_2
XFILLER_42_157 VGND VGND VPWR VPWR sky130_fd_sc_hd__fill_1
XFILLER_42_124 VGND VGND VPWR VPWR sky130_fd_sc_hd__fill_1
XFILLER_2_253 VGND VGND VPWR VPWR sky130_fd_sc_hd__decap_6
XFILLER_18_165 VPWR VGND VPWR VGND sky130_ef_sc_hd__decap_12
XFILLER_33_113 VPWR VGND VPWR VGND sky130_ef_sc_hd__decap_12
XFILLER_24_124 VGND VGND VPWR VPWR sky130_fd_sc_hd__decap_4
XFILLER_24_135 VGND VGND VPWR VPWR sky130_fd_sc_hd__decap_4
XFILLER_21_57 VPWR VGND VPWR VGND sky130_ef_sc_hd__decap_12
X_760_ net45 net57 _230_ VGND VGND VPWR VPWR _233_ sky130_fd_sc_hd__a21oi_1
X_691_ net66 net44 _159_ _161_ VGND VGND VPWR VPWR _162_ sky130_fd_sc_hd__a22oi_1
XFILLER_7_15 VPWR VGND VPWR VGND sky130_ef_sc_hd__decap_12
XFILLER_38_238 VPWR VGND VPWR VGND sky130_ef_sc_hd__decap_12
X_889_ _368_ _369_ VGND VGND VPWR VPWR _371_ sky130_fd_sc_hd__xnor2_1
XFILLER_21_116 VPWR VGND VPWR VGND sky130_ef_sc_hd__decap_12
XFILLER_8_109 VPWR VGND VPWR VGND sky130_ef_sc_hd__decap_12
X_743_ net58 _213_ VGND VGND VPWR VPWR _214_ sky130_fd_sc_hd__xnor2_1
X_674_ net50 _144_ _107_ VGND VGND VPWR VPWR _145_ sky130_fd_sc_hd__a21oi_1
X_812_ _280_ _285_ _286_ VGND VGND VPWR VPWR _288_ sky130_fd_sc_hd__or3_1
XFILLER_11_193 VPWR VGND VPWR VGND sky130_ef_sc_hd__decap_12
XFILLER_21_3 VPWR VGND VPWR VGND sky130_ef_sc_hd__decap_12
XTAP_TAPCELL_ROW_36_258 VGND VPWR sky130_fd_sc_hd__tapvpwrvgnd_1
XTAP_TAPCELL_ROW_4_112 VGND VPWR sky130_fd_sc_hd__tapvpwrvgnd_1
XTAP_TAPCELL_ROW_27_214 VGND VPWR sky130_fd_sc_hd__tapvpwrvgnd_1
XFILLER_4_189 VGND VGND VPWR VPWR sky130_fd_sc_hd__decap_6
XFILLER_4_27 VGND VGND VPWR VPWR sky130_fd_sc_hd__fill_1
X_726_ net13 net7 _171_ VGND VGND VPWR VPWR _196_ sky130_fd_sc_hd__a21o_1
X_657_ _095_ _098_ _127_ net48 VGND VGND VPWR VPWR _128_ sky130_fd_sc_hd__a211o_1
X_588_ _035_ _039_ _058_ VGND VGND VPWR VPWR _059_ sky130_fd_sc_hd__or3b_1
XFILLER_31_233 VGND VGND VPWR VPWR sky130_fd_sc_hd__fill_2
Xfanout37 net9 VGND VGND VPWR VPWR net37 sky130_fd_sc_hd__clkbuf_4
XFILLER_13_69 VPWR VGND VPWR VGND sky130_ef_sc_hd__decap_12
XFILLER_22_244 VGND VGND VPWR VPWR sky130_fd_sc_hd__decap_8
Xfanout59 net61 VGND VGND VPWR VPWR net59 sky130_fd_sc_hd__clkbuf_4
Xfanout48 net20 VGND VGND VPWR VPWR net48 sky130_fd_sc_hd__clkbuf_4
XFILLER_1_137 VPWR VGND VPWR VGND sky130_ef_sc_hd__decap_12
X_511_ _412_ _419_ _421_ _408_ VGND VGND VPWR VPWR _440_ sky130_fd_sc_hd__a211o_2
XFILLER_9_237 VPWR VGND VPWR VGND sky130_ef_sc_hd__decap_12
XFILLER_13_222 VGND VGND VPWR VPWR sky130_fd_sc_hd__fill_2
XFILLER_0_181 VPWR VGND VPWR VGND sky130_ef_sc_hd__decap_12
X_709_ _165_ _175_ _177_ _174_ net45 VGND VGND VPWR VPWR _179_ sky130_fd_sc_hd__a32o_1
XFILLER_5_81 VPWR VGND VPWR VGND sky130_ef_sc_hd__decap_12
XFILLER_24_13 VGND VGND VPWR VPWR sky130_fd_sc_hd__decap_4
XFILLER_24_24 VGND VGND VPWR VPWR sky130_fd_sc_hd__decap_4
XFILLER_1_39 VPWR VGND VPWR VGND sky130_ef_sc_hd__decap_12
XFILLER_36_111 VGND VGND VPWR VPWR sky130_fd_sc_hd__fill_1
Xinput5 op_a[0] VGND VGND VPWR VPWR net5 sky130_fd_sc_hd__clkbuf_1
XFILLER_36_188 VGND VGND VPWR VPWR sky130_fd_sc_hd__decap_8
XFILLER_36_177 VGND VGND VPWR VPWR sky130_fd_sc_hd__decap_3
XFILLER_10_15 VPWR VGND VPWR VGND sky130_ef_sc_hd__decap_12
XFILLER_19_57 VPWR VGND VPWR VGND sky130_ef_sc_hd__decap_12
XFILLER_2_221 VPWR VGND VPWR VGND sky130_ef_sc_hd__decap_12
XFILLER_18_177 VGND VGND VPWR VPWR sky130_fd_sc_hd__decap_6
XFILLER_33_125 VGND VGND VPWR VPWR sky130_fd_sc_hd__decap_8
XFILLER_33_169 VGND VGND VPWR VPWR sky130_fd_sc_hd__fill_1
XFILLER_21_69 VGND VGND VPWR VPWR sky130_fd_sc_hd__decap_3
X_690_ net3 net47 _284_ _158_ VGND VGND VPWR VPWR _161_ sky130_fd_sc_hd__or4b_4
XFILLER_7_27 VPWR VGND VPWR VGND sky130_ef_sc_hd__decap_12
X_888_ net51 _160_ _321_ VGND VGND VPWR VPWR _369_ sky130_fd_sc_hd__a21o_1
XFILLER_14_180 VGND VGND VPWR VPWR sky130_fd_sc_hd__fill_1
XTAP_TAPCELL_ROW_16_164 VGND VPWR sky130_fd_sc_hd__tapvpwrvgnd_1
XFILLER_21_128 VGND VGND VPWR VPWR sky130_fd_sc_hd__fill_2
XFILLER_29_206 VGND VGND VPWR VPWR sky130_fd_sc_hd__decap_3
XFILLER_12_139 VGND VGND VPWR VPWR sky130_fd_sc_hd__fill_1
X_811_ _285_ _286_ VGND VGND VPWR VPWR _287_ sky130_fd_sc_hd__nor2_1
X_742_ net66 net64 net61 _160_ VGND VGND VPWR VPWR _213_ sky130_fd_sc_hd__o31a_1
X_673_ _104_ _106_ VGND VGND VPWR VPWR _144_ sky130_fd_sc_hd__nor2_1
XFILLER_35_209 VGND VGND VPWR VPWR sky130_fd_sc_hd__decap_3
XFILLER_43_253 VGND VGND VPWR VPWR sky130_fd_sc_hd__decap_6
XFILLER_11_161 VGND VGND VPWR VPWR sky130_fd_sc_hd__decap_6
XFILLER_14_3 VPWR VGND VPWR VGND sky130_ef_sc_hd__decap_12
XFILLER_34_253 VGND VGND VPWR VPWR sky130_fd_sc_hd__decap_6
XTAP_TAPCELL_ROW_4_113 VGND VPWR sky130_fd_sc_hd__tapvpwrvgnd_1
XTAP_TAPCELL_ROW_27_215 VGND VPWR sky130_fd_sc_hd__tapvpwrvgnd_1
XFILLER_25_220 VGND VGND VPWR VPWR sky130_fd_sc_hd__decap_4
XTAP_TAPCELL_ROW_10_137 VGND VPWR sky130_fd_sc_hd__tapvpwrvgnd_1
X_725_ _183_ _185_ _193_ _161_ VGND VGND VPWR VPWR _195_ sky130_fd_sc_hd__a31oi_1
XFILLER_16_231 VPWR VGND VPWR VGND sky130_ef_sc_hd__decap_12
XFILLER_16_253 VGND VGND VPWR VPWR sky130_fd_sc_hd__decap_3
X_587_ _047_ _053_ _045_ VGND VGND VPWR VPWR _058_ sky130_fd_sc_hd__a21o_1
X_656_ _078_ _126_ VGND VGND VPWR VPWR _127_ sky130_fd_sc_hd__xnor2_1
XFILLER_31_223 VGND VGND VPWR VPWR sky130_fd_sc_hd__fill_1
XFILLER_13_15 VPWR VGND VPWR VGND sky130_ef_sc_hd__decap_12
Xfanout38 net8 VGND VGND VPWR VPWR net38 sky130_fd_sc_hd__clkbuf_4
XTAP_TAPCELL_ROW_32_240 VGND VPWR sky130_fd_sc_hd__tapvpwrvgnd_1
Xfanout49 net20 VGND VGND VPWR VPWR net49 sky130_fd_sc_hd__clkbuf_2
XFILLER_38_45 VGND VGND VPWR VPWR sky130_fd_sc_hd__fill_2
XFILLER_1_105 VGND VGND VPWR VPWR sky130_fd_sc_hd__decap_6
XFILLER_1_149 VPWR VGND VPWR VGND sky130_ef_sc_hd__decap_12
X_510_ _403_ _423_ _392_ VGND VGND VPWR VPWR _439_ sky130_fd_sc_hd__a21o_1
XFILLER_9_249 VGND VGND VPWR VPWR sky130_fd_sc_hd__decap_8
XFILLER_9_205 VPWR VGND VPWR VGND sky130_ef_sc_hd__decap_12
XFILLER_0_193 VGND VGND VPWR VPWR sky130_fd_sc_hd__decap_3
X_708_ net40 _168_ _171_ _166_ VGND VGND VPWR VPWR _178_ sky130_fd_sc_hd__a22o_1
X_639_ _069_ _079_ _092_ _090_ net58 VGND VGND VPWR VPWR _110_ sky130_fd_sc_hd__o32a_1
XFILLER_5_93 VPWR VGND VPWR VGND sky130_ef_sc_hd__decap_12
XFILLER_36_101 VGND VGND VPWR VPWR sky130_fd_sc_hd__fill_1
Xinput6 op_a[1] VGND VGND VPWR VPWR net6 sky130_fd_sc_hd__buf_1
XFILLER_10_27 VGND VGND VPWR VPWR sky130_fd_sc_hd__fill_1
XFILLER_19_69 VGND VGND VPWR VPWR sky130_fd_sc_hd__fill_1
XFILLER_35_24 VGND VGND VPWR VPWR sky130_fd_sc_hd__decap_8
XFILLER_35_57 VPWR VGND VPWR VGND sky130_ef_sc_hd__decap_12
XPHY_EDGE_ROW_14_Right_14 VGND VGND VPWR VPWR sky130_fd_sc_hd__decap_3
XFILLER_2_233 VPWR VGND VPWR VGND sky130_ef_sc_hd__decap_12
XPHY_EDGE_ROW_23_Right_23 VGND VGND VPWR VPWR sky130_fd_sc_hd__decap_3
XFILLER_18_101 VGND VGND VPWR VPWR sky130_fd_sc_hd__fill_1
XFILLER_18_112 VGND VGND VPWR VPWR sky130_fd_sc_hd__decap_3
XPHY_EDGE_ROW_32_Right_32 VGND VGND VPWR VPWR sky130_fd_sc_hd__decap_3
XPHY_EDGE_ROW_41_Right_41 VGND VGND VPWR VPWR sky130_fd_sc_hd__decap_3
XFILLER_2_83 VGND VGND VPWR VPWR sky130_fd_sc_hd__fill_1
XFILLER_21_15 VPWR VGND VPWR VGND sky130_ef_sc_hd__decap_12
XFILLER_23_181 VPWR VGND VPWR VGND sky130_ef_sc_hd__decap_12
XFILLER_7_39 VPWR VGND VPWR VGND sky130_ef_sc_hd__decap_12
XFILLER_11_81 VPWR VGND VPWR VGND sky130_ef_sc_hd__decap_12
X_887_ net12 net49 VGND VGND VPWR VPWR _368_ sky130_fd_sc_hd__xnor2_1
XTAP_TAPCELL_ROW_16_165 VGND VPWR sky130_fd_sc_hd__tapvpwrvgnd_1
Xinput20 op_b[7] VGND VGND VPWR VPWR net20 sky130_fd_sc_hd__clkbuf_1
XTAP_TAPCELL_ROW_39_268 VGND VPWR sky130_fd_sc_hd__tapvpwrvgnd_1
XFILLER_16_15 VPWR VGND VPWR VGND sky130_ef_sc_hd__decap_12
XFILLER_20_184 VPWR VGND VPWR VGND sky130_ef_sc_hd__decap_12
XFILLER_32_58 VGND VGND VPWR VPWR sky130_fd_sc_hd__decap_8
X_810_ _281_ _282_ _283_ VGND VGND VPWR VPWR _286_ sky130_fd_sc_hd__nor3_1
XFILLER_43_221 VGND VGND VPWR VPWR sky130_fd_sc_hd__decap_3
X_741_ _194_ _195_ _212_ VGND VGND VPWR VPWR net23 sky130_fd_sc_hd__a21o_1
X_672_ _113_ _118_ _119_ _142_ _114_ VGND VGND VPWR VPWR _143_ sky130_fd_sc_hd__o221a_1
XFILLER_28_251 VGND VGND VPWR VPWR sky130_fd_sc_hd__fill_1
XFILLER_7_111 VGND VGND VPWR VPWR sky130_fd_sc_hd__fill_1
XTAP_TAPCELL_ROW_21_190 VGND VPWR sky130_fd_sc_hd__tapvpwrvgnd_1
XFILLER_22_91 VPWR VGND VPWR VGND sky130_ef_sc_hd__decap_12
XPHY_EDGE_ROW_14_Left_58 VGND VGND VPWR VPWR sky130_fd_sc_hd__decap_3
XFILLER_34_243 VGND VGND VPWR VPWR sky130_fd_sc_hd__decap_8
XTAP_TAPCELL_ROW_4_114 VGND VPWR sky130_fd_sc_hd__tapvpwrvgnd_1
XPHY_EDGE_ROW_4_Right_4 VGND VGND VPWR VPWR sky130_fd_sc_hd__decap_3
XFILLER_27_14 VGND VGND VPWR VPWR sky130_fd_sc_hd__fill_2
XFILLER_27_25 VPWR VGND VPWR VGND sky130_ef_sc_hd__decap_12
XTAP_TAPCELL_ROW_27_216 VGND VPWR sky130_fd_sc_hd__tapvpwrvgnd_1
XFILLER_43_57 VPWR VGND VPWR VGND sky130_ef_sc_hd__decap_12
XTAP_TAPCELL_ROW_10_138 VGND VPWR sky130_fd_sc_hd__tapvpwrvgnd_1
XFILLER_4_29 VPWR VGND VPWR VGND sky130_ef_sc_hd__decap_12
X_724_ _183_ _185_ _193_ VGND VGND VPWR VPWR _194_ sky130_fd_sc_hd__a21o_1
XFILLER_16_221 VGND VGND VPWR VPWR sky130_fd_sc_hd__decap_3
XFILLER_16_243 VGND VGND VPWR VPWR sky130_fd_sc_hd__decap_8
XFILLER_17_80 VPWR VGND VPWR VGND sky130_ef_sc_hd__decap_12
X_586_ _035_ _039_ _056_ _030_ VGND VGND VPWR VPWR _057_ sky130_fd_sc_hd__or4b_1
X_655_ _068_ _069_ VGND VGND VPWR VPWR _126_ sky130_fd_sc_hd__or2_1
XFILLER_31_257 VGND VGND VPWR VPWR sky130_fd_sc_hd__fill_2
Xfanout39 net8 VGND VGND VPWR VPWR net39 sky130_fd_sc_hd__dlymetal6s2s_1
XFILLER_13_27 VPWR VGND VPWR VGND sky130_ef_sc_hd__decap_12
XFILLER_9_217 VGND VGND VPWR VPWR sky130_fd_sc_hd__decap_6
X_707_ _176_ VGND VGND VPWR VPWR _177_ sky130_fd_sc_hd__inv_2
XFILLER_28_90 VPWR VGND VPWR VGND sky130_ef_sc_hd__decap_12
X_638_ _106_ _107_ _108_ VGND VGND VPWR VPWR _109_ sky130_fd_sc_hd__or3_1
X_569_ _263_ _452_ VGND VGND VPWR VPWR _040_ sky130_fd_sc_hd__xnor2_1
XFILLER_6_209 VPWR VGND VPWR VGND sky130_ef_sc_hd__decap_12
XPHY_EDGE_ROW_17_Left_61 VGND VGND VPWR VPWR sky130_fd_sc_hd__decap_3
Xinput7 op_a[2] VGND VGND VPWR VPWR net7 sky130_fd_sc_hd__dlymetal6s2s_1
XFILLER_19_15 VPWR VGND VPWR VGND sky130_ef_sc_hd__decap_12
XFILLER_27_113 VPWR VGND VPWR VGND sky130_ef_sc_hd__decap_12
XFILLER_42_138 VGND VGND VPWR VPWR sky130_fd_sc_hd__fill_2
XFILLER_27_179 VPWR VGND VPWR VGND sky130_ef_sc_hd__decap_12
XFILLER_35_69 VGND VGND VPWR VPWR sky130_fd_sc_hd__decap_4
XPHY_EDGE_ROW_2_Left_46 VGND VGND VPWR VPWR sky130_fd_sc_hd__decap_3
XFILLER_4_3 VPWR VGND VPWR VGND sky130_ef_sc_hd__decap_12
XFILLER_2_245 VGND VGND VPWR VPWR sky130_fd_sc_hd__decap_6
XFILLER_18_124 VGND VGND VPWR VPWR sky130_fd_sc_hd__fill_1
XFILLER_33_105 VGND VGND VPWR VPWR sky130_fd_sc_hd__decap_6
XFILLER_25_91 VGND VGND VPWR VPWR sky130_fd_sc_hd__decap_3
XFILLER_37_3 VPWR VGND VPWR VGND sky130_ef_sc_hd__decap_12
XFILLER_21_27 VPWR VGND VPWR VGND sky130_ef_sc_hd__decap_12
XFILLER_32_160 VPWR VGND VPWR VGND sky130_ef_sc_hd__decap_12
XFILLER_15_116 VGND VGND VPWR VPWR sky130_fd_sc_hd__decap_3
XFILLER_23_193 VPWR VGND VPWR VGND sky130_ef_sc_hd__decap_12
XFILLER_11_93 VPWR VGND VPWR VGND sky130_ef_sc_hd__decap_12
X_886_ net68 _323_ _325_ VGND VGND VPWR VPWR _367_ sky130_fd_sc_hd__a21oi_1
Xinput10 op_a[5] VGND VGND VPWR VPWR net10 sky130_fd_sc_hd__clkbuf_2
XFILLER_14_160 VGND VGND VPWR VPWR sky130_fd_sc_hd__decap_4
XTAP_TAPCELL_ROW_16_166 VGND VPWR sky130_fd_sc_hd__tapvpwrvgnd_1
XTAP_TAPCELL_ROW_39_269 VGND VPWR sky130_fd_sc_hd__tapvpwrvgnd_1
XFILLER_16_27 VGND VGND VPWR VPWR sky130_fd_sc_hd__fill_1
XFILLER_32_26 VGND VGND VPWR VPWR sky130_fd_sc_hd__fill_2
X_740_ _295_ net30 _209_ _211_ VGND VGND VPWR VPWR _212_ sky130_fd_sc_hd__a211o_1
X_671_ _132_ _140_ _141_ _130_ VGND VGND VPWR VPWR _142_ sky130_fd_sc_hd__o211a_1
XFILLER_7_167 VGND VGND VPWR VPWR sky130_fd_sc_hd__fill_1
X_869_ _337_ _347_ VGND VGND VPWR VPWR _350_ sky130_fd_sc_hd__xor2_1
XFILLER_8_83 VGND VGND VPWR VPWR sky130_fd_sc_hd__fill_1
XFILLER_27_37 VGND VGND VPWR VPWR sky130_fd_sc_hd__decap_4
XTAP_TAPCELL_ROW_27_217 VGND VPWR sky130_fd_sc_hd__tapvpwrvgnd_1
XFILLER_43_69 VPWR VGND VPWR VGND sky130_ef_sc_hd__decap_12
XTAP_TAPCELL_ROW_10_139 VGND VPWR sky130_fd_sc_hd__tapvpwrvgnd_1
XTAP_TAPCELL_ROW_35_250 VGND VPWR sky130_fd_sc_hd__tapvpwrvgnd_1
X_723_ _191_ _192_ VGND VGND VPWR VPWR _193_ sky130_fd_sc_hd__nand2_1
X_654_ _072_ net29 _122_ _263_ VGND VGND VPWR VPWR _125_ sky130_fd_sc_hd__o211a_1
XPHY_EDGE_ROW_31_Left_75 VGND VGND VPWR VPWR sky130_fd_sc_hd__decap_3
XFILLER_17_92 VPWR VGND VPWR VGND sky130_ef_sc_hd__decap_12
X_585_ _045_ _046_ _053_ _054_ VGND VGND VPWR VPWR _056_ sky130_fd_sc_hd__or4_1
XFILLER_31_225 VGND VGND VPWR VPWR sky130_fd_sc_hd__decap_8
XFILLER_3_181 VPWR VGND VPWR VGND sky130_ef_sc_hd__decap_12
XFILLER_13_39 VPWR VGND VPWR VGND sky130_ef_sc_hd__decap_12
XFILLER_22_203 VPWR VGND VPWR VGND sky130_ef_sc_hd__decap_12
Xfanout29 _099_ VGND VGND VPWR VPWR net29 sky130_fd_sc_hd__clkbuf_4
XFILLER_13_214 VGND VGND VPWR VPWR sky130_fd_sc_hd__fill_2
X_706_ net66 net44 _171_ VGND VGND VPWR VPWR _176_ sky130_fd_sc_hd__and3_1
X_637_ net50 _104_ VGND VGND VPWR VPWR _108_ sky130_fd_sc_hd__xor2_1
X_499_ _263_ _425_ _426_ VGND VGND VPWR VPWR _428_ sky130_fd_sc_hd__and3_1
X_568_ _037_ _038_ VGND VGND VPWR VPWR _039_ sky130_fd_sc_hd__nand2b_1
XFILLER_8_251 VGND VGND VPWR VPWR sky130_fd_sc_hd__fill_1
XFILLER_5_51 VGND VGND VPWR VPWR sky130_fd_sc_hd__decap_4
XFILLER_39_177 VGND VGND VPWR VPWR sky130_fd_sc_hd__decap_4
XFILLER_39_111 VGND VGND VPWR VPWR sky130_fd_sc_hd__fill_1
XFILLER_40_15 VPWR VGND VPWR VGND sky130_ef_sc_hd__decap_12
XFILLER_39_90 VPWR VGND VPWR VGND sky130_ef_sc_hd__decap_12
Xinput8 op_a[3] VGND VGND VPWR VPWR net8 sky130_fd_sc_hd__buf_1
XFILLER_36_169 VGND VGND VPWR VPWR sky130_fd_sc_hd__decap_8
XFILLER_36_158 VGND VGND VPWR VPWR sky130_fd_sc_hd__decap_4
XFILLER_10_29 VPWR VGND VPWR VGND sky130_ef_sc_hd__decap_12
XFILLER_19_27 VPWR VGND VPWR VGND sky130_ef_sc_hd__decap_12
XFILLER_27_125 VPWR VGND VPWR VGND sky130_ef_sc_hd__decap_12
XFILLER_42_117 VGND VGND VPWR VPWR sky130_fd_sc_hd__fill_2
XFILLER_35_191 VGND VGND VPWR VPWR sky130_fd_sc_hd__decap_3
XFILLER_2_41 VPWR VGND VPWR VGND sky130_ef_sc_hd__decap_12
XFILLER_2_85 VPWR VGND VPWR VGND sky130_ef_sc_hd__decap_12
XFILLER_24_128 VGND VGND VPWR VPWR sky130_fd_sc_hd__fill_1
XFILLER_24_139 VGND VGND VPWR VPWR sky130_fd_sc_hd__fill_1
XFILLER_32_172 VPWR VGND VPWR VGND sky130_ef_sc_hd__decap_12
XFILLER_21_39 VGND VGND VPWR VPWR sky130_fd_sc_hd__fill_1
XFILLER_30_109 VPWR VGND VPWR VGND sky130_ef_sc_hd__decap_12
X_885_ net32 _359_ _361_ _366_ VGND VGND VPWR VPWR net27 sky130_fd_sc_hd__a31o_1
XTAP_TAPCELL_ROW_16_167 VGND VPWR sky130_fd_sc_hd__tapvpwrvgnd_1
Xinput11 op_a[6] VGND VGND VPWR VPWR net11 sky130_fd_sc_hd__buf_1
XFILLER_12_109 VPWR VGND VPWR VGND sky130_ef_sc_hd__decap_12
XFILLER_20_197 VGND VGND VPWR VPWR sky130_fd_sc_hd__fill_1
XTAP_TAPCELL_ROW_7_124 VGND VPWR sky130_fd_sc_hd__tapvpwrvgnd_1
XFILLER_28_220 VGND VGND VPWR VPWR sky130_fd_sc_hd__decap_8
X_670_ _131_ _124_ VGND VGND VPWR VPWR _141_ sky130_fd_sc_hd__nand2b_1
XFILLER_28_253 VGND VGND VPWR VPWR sky130_fd_sc_hd__decap_6
XFILLER_7_113 VPWR VGND VPWR VGND sky130_ef_sc_hd__decap_12
XFILLER_22_71 VGND VGND VPWR VPWR sky130_fd_sc_hd__decap_8
X_868_ _347_ VGND VGND VPWR VPWR _348_ sky130_fd_sc_hd__inv_2
X_799_ net44 net52 VGND VGND VPWR VPWR _274_ sky130_fd_sc_hd__nand2_1
XFILLER_34_223 VPWR VGND VPWR VGND sky130_ef_sc_hd__decap_12
XFILLER_43_15 VPWR VGND VPWR VGND sky130_ef_sc_hd__decap_12
XFILLER_25_234 VPWR VGND VPWR VGND sky130_ef_sc_hd__decap_12
XTAP_TAPCELL_ROW_35_251 VGND VPWR sky130_fd_sc_hd__tapvpwrvgnd_1
X_722_ net41 _190_ VGND VGND VPWR VPWR _192_ sky130_fd_sc_hd__nand2_1
X_653_ _073_ net29 _123_ net59 VGND VGND VPWR VPWR _124_ sky130_fd_sc_hd__o211a_1
X_584_ _053_ _054_ VGND VGND VPWR VPWR _055_ sky130_fd_sc_hd__nor2_1
XFILLER_3_193 VPWR VGND VPWR VGND sky130_ef_sc_hd__decap_12
XFILLER_12_3 VPWR VGND VPWR VGND sky130_ef_sc_hd__decap_12
XFILLER_22_215 VPWR VGND VPWR VGND sky130_ef_sc_hd__decap_12
XFILLER_38_37 VGND VGND VPWR VPWR sky130_fd_sc_hd__fill_1
XFILLER_38_15 VPWR VGND VPWR VGND sky130_ef_sc_hd__decap_12
XFILLER_0_141 VPWR VGND VPWR VGND sky130_ef_sc_hd__decap_12
X_705_ net66 net6 net64 net44 VGND VGND VPWR VPWR _175_ sky130_fd_sc_hd__a22o_1
X_636_ net48 _440_ _105_ VGND VGND VPWR VPWR _107_ sky130_fd_sc_hd__and3_1
X_567_ _440_ _036_ net52 VGND VGND VPWR VPWR _038_ sky130_fd_sc_hd__a21o_1
X_498_ _425_ _426_ VGND VGND VPWR VPWR _427_ sky130_fd_sc_hd__nand2_1
XFILLER_39_134 VGND VGND VPWR VPWR sky130_fd_sc_hd__decap_3
XFILLER_40_27 VGND VGND VPWR VPWR sky130_fd_sc_hd__fill_1
XFILLER_14_83 VGND VGND VPWR VPWR sky130_fd_sc_hd__fill_1
XFILLER_30_71 VGND VGND VPWR VPWR sky130_fd_sc_hd__fill_1
XTAP_TAPCELL_ROW_1_97 VGND VPWR sky130_fd_sc_hd__tapvpwrvgnd_1
Xinput9 op_a[4] VGND VGND VPWR VPWR net9 sky130_fd_sc_hd__clkbuf_1
X_619_ _052_ _089_ net30 VGND VGND VPWR VPWR _090_ sky130_fd_sc_hd__mux2_2
XFILLER_19_39 VPWR VGND VPWR VGND sky130_ef_sc_hd__decap_12
XFILLER_27_137 VGND VGND VPWR VPWR sky130_fd_sc_hd__decap_6
XFILLER_18_137 VGND VGND VPWR VPWR sky130_fd_sc_hd__decap_3
XFILLER_25_71 VPWR VGND VPWR VGND sky130_ef_sc_hd__decap_12
XFILLER_26_181 VPWR VGND VPWR VGND sky130_ef_sc_hd__decap_12
XFILLER_41_184 VGND VGND VPWR VPWR sky130_fd_sc_hd__decap_4
XPHY_EDGE_ROW_10_Right_10 VGND VGND VPWR VPWR sky130_fd_sc_hd__decap_3
XFILLER_2_53 VPWR VGND VPWR VGND sky130_ef_sc_hd__decap_12
XFILLER_2_97 VPWR VGND VPWR VGND sky130_ef_sc_hd__decap_12
XFILLER_32_184 VPWR VGND VPWR VGND sky130_ef_sc_hd__decap_12
XFILLER_11_51 VGND VGND VPWR VPWR sky130_fd_sc_hd__decap_4
X_884_ _295_ _409_ _328_ _365_ VGND VGND VPWR VPWR _366_ sky130_fd_sc_hd__a211o_1
XTAP_TAPCELL_ROW_16_168 VGND VPWR sky130_fd_sc_hd__tapvpwrvgnd_1
Xinput12 op_a[7] VGND VGND VPWR VPWR net12 sky130_fd_sc_hd__clkbuf_4
XFILLER_42_3 VPWR VGND VPWR VGND sky130_ef_sc_hd__decap_12
XFILLER_16_29 VPWR VGND VPWR VGND sky130_ef_sc_hd__decap_12
XTAP_TAPCELL_ROW_7_125 VGND VPWR sky130_fd_sc_hd__tapvpwrvgnd_1
XFILLER_43_213 VGND VGND VPWR VPWR sky130_fd_sc_hd__decap_8
XFILLER_7_169 VPWR VGND VPWR VGND sky130_ef_sc_hd__decap_12
XFILLER_7_125 VPWR VGND VPWR VGND sky130_ef_sc_hd__decap_12
X_798_ _161_ _247_ _248_ _272_ VGND VGND VPWR VPWR net25 sky130_fd_sc_hd__o31ai_1
X_867_ _345_ _346_ VGND VGND VPWR VPWR _347_ sky130_fd_sc_hd__or2_1
XFILLER_34_235 VGND VGND VPWR VPWR sky130_fd_sc_hd__decap_3
XFILLER_8_85 VPWR VGND VPWR VGND sky130_ef_sc_hd__decap_12
XFILLER_8_41 VPWR VGND VPWR VGND sky130_ef_sc_hd__decap_12
XFILLER_43_27 VGND VGND VPWR VPWR sky130_fd_sc_hd__fill_1
XTAP_TAPCELL_ROW_35_252 VGND VPWR sky130_fd_sc_hd__tapvpwrvgnd_1
XFILLER_25_246 VPWR VGND VPWR VGND sky130_ef_sc_hd__decap_12
XFILLER_4_139 VGND VGND VPWR VPWR sky130_fd_sc_hd__fill_1
X_721_ net41 _190_ VGND VGND VPWR VPWR _191_ sky130_fd_sc_hd__or2_1
X_583_ net59 _050_ _051_ VGND VGND VPWR VPWR _054_ sky130_fd_sc_hd__and3_1
X_652_ _095_ _098_ _121_ net48 VGND VGND VPWR VPWR _123_ sky130_fd_sc_hd__a211o_1
XTAP_TAPCELL_ROW_41_277 VGND VPWR sky130_fd_sc_hd__tapvpwrvgnd_1
XFILLER_31_205 VPWR VGND VPWR VGND sky130_ef_sc_hd__decap_12
XFILLER_33_82 VGND VGND VPWR VPWR sky130_fd_sc_hd__fill_1
XFILLER_33_93 VPWR VGND VPWR VGND sky130_ef_sc_hd__decap_12
XFILLER_3_161 VGND VGND VPWR VPWR sky130_fd_sc_hd__decap_6
X_919_ net12 net49 _159_ VGND VGND VPWR VPWR _404_ sky130_fd_sc_hd__a21oi_1
XPHY_EDGE_ROW_8_Right_8 VGND VGND VPWR VPWR sky130_fd_sc_hd__decap_3
XFILLER_22_227 VPWR VGND VPWR VGND sky130_ef_sc_hd__decap_12
XPHY_EDGE_ROW_39_Right_39 VGND VGND VPWR VPWR sky130_fd_sc_hd__decap_3
XFILLER_38_27 VGND VGND VPWR VPWR sky130_fd_sc_hd__fill_1
X_704_ net1 net4 net3 net2 VGND VGND VPWR VPWR _174_ sky130_fd_sc_hd__and4bb_2
XFILLER_0_153 VPWR VGND VPWR VGND sky130_ef_sc_hd__decap_12
XFILLER_0_197 VPWR VGND VPWR VGND sky130_ef_sc_hd__decap_12
X_635_ _440_ _105_ net48 VGND VGND VPWR VPWR _106_ sky130_fd_sc_hd__a21oi_1
X_566_ net52 _440_ _036_ VGND VGND VPWR VPWR _037_ sky130_fd_sc_hd__and3_1
XFILLER_8_253 VGND VGND VPWR VPWR sky130_fd_sc_hd__decap_6
X_497_ _419_ _424_ _422_ _408_ VGND VGND VPWR VPWR _426_ sky130_fd_sc_hd__a211o_1
XFILLER_39_113 VPWR VGND VPWR VGND sky130_ef_sc_hd__decap_12
XFILLER_39_102 VGND VGND VPWR VPWR sky130_fd_sc_hd__decap_4
XFILLER_5_223 VGND VGND VPWR VPWR sky130_fd_sc_hd__fill_1
XTAP_TAPCELL_ROW_1_98 VGND VPWR sky130_fd_sc_hd__tapvpwrvgnd_1
XFILLER_36_149 VGND VGND VPWR VPWR sky130_fd_sc_hd__fill_1
XFILLER_36_138 VGND VGND VPWR VPWR sky130_fd_sc_hd__fill_2
XFILLER_36_105 VGND VGND VPWR VPWR sky130_fd_sc_hd__decap_6
X_549_ _006_ _007_ _014_ _018_ VGND VGND VPWR VPWR _020_ sky130_fd_sc_hd__or4_1
X_618_ _030_ _055_ VGND VGND VPWR VPWR _089_ sky130_fd_sc_hd__xnor2_1
XFILLER_41_141 VPWR VGND VPWR VGND sky130_ef_sc_hd__decap_12
XFILLER_25_83 VGND VGND VPWR VPWR sky130_fd_sc_hd__decap_8
XFILLER_26_193 VGND VGND VPWR VPWR sky130_fd_sc_hd__decap_3
XFILLER_2_65 VPWR VGND VPWR VGND sky130_ef_sc_hd__decap_12
XFILLER_15_108 VGND VGND VPWR VPWR sky130_fd_sc_hd__decap_4
XFILLER_2_3 VPWR VGND VPWR VGND sky130_ef_sc_hd__decap_12
X_883_ net12 _168_ _363_ _364_ VGND VGND VPWR VPWR _365_ sky130_fd_sc_hd__a211o_1
XFILLER_14_152 VGND VGND VPWR VPWR sky130_fd_sc_hd__decap_3
Xinput13 op_b[0] VGND VGND VPWR VPWR net13 sky130_fd_sc_hd__clkbuf_2
XFILLER_20_100 VGND VGND VPWR VPWR sky130_fd_sc_hd__decap_4
XFILLER_32_18 VGND VGND VPWR VPWR sky130_fd_sc_hd__decap_3
XFILLER_32_29 VGND VGND VPWR VPWR sky130_fd_sc_hd__decap_4
XTAP_TAPCELL_ROW_7_126 VGND VPWR sky130_fd_sc_hd__tapvpwrvgnd_1
XFILLER_43_225 VPWR VGND VPWR VGND sky130_ef_sc_hd__decap_12
XFILLER_28_211 VGND VGND VPWR VPWR sky130_fd_sc_hd__decap_4
XFILLER_11_111 VGND VGND VPWR VPWR sky130_fd_sc_hd__fill_1
XFILLER_7_137 VPWR VGND VPWR VGND sky130_ef_sc_hd__decap_12
X_866_ _282_ _286_ _344_ VGND VGND VPWR VPWR _346_ sky130_fd_sc_hd__o21a_1
X_797_ _295_ _444_ _270_ _271_ VGND VGND VPWR VPWR _272_ sky130_fd_sc_hd__a211oi_1
XFILLER_8_97 VPWR VGND VPWR VGND sky130_ef_sc_hd__decap_12
XFILLER_8_53 VPWR VGND VPWR VGND sky130_ef_sc_hd__decap_12
XTAP_TAPCELL_ROW_12_150 VGND VPWR sky130_fd_sc_hd__tapvpwrvgnd_1
XFILLER_40_217 VPWR VGND VPWR VGND sky130_ef_sc_hd__decap_12
XTAP_TAPCELL_ROW_35_253 VGND VPWR sky130_fd_sc_hd__tapvpwrvgnd_1
XFILLER_25_225 VGND VGND VPWR VPWR sky130_fd_sc_hd__decap_4
XFILLER_25_258 VGND VGND VPWR VPWR sky130_fd_sc_hd__fill_1
X_720_ net59 _189_ VGND VGND VPWR VPWR _190_ sky130_fd_sc_hd__xnor2_1
XPHY_EDGE_ROW_9_Left_53 VGND VGND VPWR VPWR sky130_fd_sc_hd__decap_3
X_582_ _050_ _051_ net59 VGND VGND VPWR VPWR _053_ sky130_fd_sc_hd__a21oi_1
X_651_ _095_ _098_ _120_ _077_ net48 VGND VGND VPWR VPWR _122_ sky130_fd_sc_hd__a221o_1
XFILLER_31_217 VGND VGND VPWR VPWR sky130_fd_sc_hd__decap_6
XTAP_TAPCELL_ROW_41_278 VGND VPWR sky130_fd_sc_hd__tapvpwrvgnd_1
X_918_ _374_ _400_ VGND VGND VPWR VPWR _402_ sky130_fd_sc_hd__nand2_1
X_849_ _325_ _326_ VGND VGND VPWR VPWR _328_ sky130_fd_sc_hd__nor2_1
XFILLER_22_239 VGND VGND VPWR VPWR sky130_fd_sc_hd__fill_1
XFILLER_13_206 VGND VGND VPWR VPWR sky130_fd_sc_hd__decap_4
XPHY_EDGE_ROW_35_Left_79 VGND VGND VPWR VPWR sky130_fd_sc_hd__decap_3
X_703_ net6 net64 _157_ _172_ VGND VGND VPWR VPWR _173_ sky130_fd_sc_hd__o22a_1
XFILLER_0_165 VGND VGND VPWR VPWR sky130_fd_sc_hd__decap_3
X_634_ _036_ net30 net29 VGND VGND VPWR VPWR _105_ sky130_fd_sc_hd__or3_1
X_496_ net67 _410_ _423_ _403_ VGND VGND VPWR VPWR _425_ sky130_fd_sc_hd__a22o_1
X_565_ _015_ _017_ _012_ VGND VGND VPWR VPWR _036_ sky130_fd_sc_hd__a21o_1
XFILLER_8_221 VPWR VGND VPWR VGND sky130_ef_sc_hd__decap_12
XFILLER_39_125 VGND VGND VPWR VPWR sky130_fd_sc_hd__decap_6
XFILLER_10_209 VPWR VGND VPWR VGND sky130_ef_sc_hd__decap_12
XFILLER_40_29 VPWR VGND VPWR VGND sky130_ef_sc_hd__decap_12
XFILLER_14_41 VPWR VGND VPWR VGND sky130_ef_sc_hd__decap_12
XFILLER_14_85 VGND VGND VPWR VPWR sky130_fd_sc_hd__fill_1
XFILLER_5_257 VGND VGND VPWR VPWR sky130_fd_sc_hd__fill_2
XTAP_TAPCELL_ROW_1_99 VGND VPWR sky130_fd_sc_hd__tapvpwrvgnd_1
X_617_ net55 _086_ VGND VGND VPWR VPWR _088_ sky130_fd_sc_hd__xor2_1
X_548_ _014_ _018_ VGND VGND VPWR VPWR _019_ sky130_fd_sc_hd__nor2_1
X_479_ _403_ VGND VGND VPWR VPWR _408_ sky130_fd_sc_hd__inv_2
XFILLER_42_109 VGND VGND VPWR VPWR sky130_fd_sc_hd__fill_2
XFILLER_41_153 VGND VGND VPWR VPWR sky130_fd_sc_hd__decap_3
XPHY_EDGE_ROW_38_Left_82 VGND VGND VPWR VPWR sky130_fd_sc_hd__decap_3
XFILLER_2_77 VGND VGND VPWR VPWR sky130_fd_sc_hd__decap_6
XPHY_EDGE_ROW_22_Left_66 VGND VGND VPWR VPWR sky130_fd_sc_hd__decap_3
XTAP_TAPCELL_ROW_19_178 VGND VPWR sky130_fd_sc_hd__tapvpwrvgnd_1
XFILLER_32_197 VPWR VGND VPWR VGND sky130_ef_sc_hd__decap_12
XFILLER_23_120 VGND VGND VPWR VPWR sky130_fd_sc_hd__decap_3
XFILLER_23_164 VGND VGND VPWR VPWR sky130_fd_sc_hd__decap_4
X_882_ net68 net51 _166_ _174_ net10 VGND VGND VPWR VPWR _364_ sky130_fd_sc_hd__a32o_1
XFILLER_36_50 VPWR VGND VPWR VGND sky130_ef_sc_hd__decap_12
XFILLER_14_164 VGND VGND VPWR VPWR sky130_fd_sc_hd__fill_1
Xinput14 op_b[1] VGND VGND VPWR VPWR net14 sky130_fd_sc_hd__clkbuf_1
XFILLER_37_256 VGND VGND VPWR VPWR sky130_fd_sc_hd__decap_3
XFILLER_37_223 VGND VGND VPWR VPWR sky130_fd_sc_hd__fill_1
XFILLER_28_3 VPWR VGND VPWR VGND sky130_ef_sc_hd__decap_12
XTAP_TAPCELL_ROW_7_127 VGND VPWR sky130_fd_sc_hd__tapvpwrvgnd_1
XFILLER_43_237 VPWR VGND VPWR VGND sky130_ef_sc_hd__decap_12
XFILLER_7_105 VGND VGND VPWR VPWR sky130_fd_sc_hd__decap_6
XFILLER_11_167 VGND VGND VPWR VPWR sky130_fd_sc_hd__fill_1
XFILLER_7_149 VPWR VGND VPWR VGND sky130_ef_sc_hd__decap_12
X_865_ _282_ _286_ _344_ VGND VGND VPWR VPWR _345_ sky130_fd_sc_hd__nor3_1
XFILLER_19_223 VGND VGND VPWR VPWR sky130_fd_sc_hd__fill_1
X_796_ net32 _265_ _266_ _268_ _269_ VGND VGND VPWR VPWR _271_ sky130_fd_sc_hd__a311o_1
XFILLER_8_65 VPWR VGND VPWR VGND sky130_ef_sc_hd__decap_12
XFILLER_43_29 VPWR VGND VPWR VGND sky130_ef_sc_hd__decap_12
XFILLER_40_229 VGND VGND VPWR VPWR sky130_fd_sc_hd__decap_4
X_650_ _077_ _120_ VGND VGND VPWR VPWR _121_ sky130_fd_sc_hd__nand2_1
X_581_ _050_ _051_ VGND VGND VPWR VPWR _052_ sky130_fd_sc_hd__and2_1
XTAP_TAPCELL_ROW_26_210 VGND VPWR sky130_fd_sc_hd__tapvpwrvgnd_1
XTAP_TAPCELL_ROW_41_279 VGND VPWR sky130_fd_sc_hd__tapvpwrvgnd_1
X_779_ _223_ _226_ _225_ VGND VGND VPWR VPWR _253_ sky130_fd_sc_hd__o21ba_1
X_917_ _374_ _400_ VGND VGND VPWR VPWR _401_ sky130_fd_sc_hd__or2_1
X_848_ _310_ _312_ _324_ _161_ VGND VGND VPWR VPWR _326_ sky130_fd_sc_hd__a31o_1
XFILLER_38_29 VGND VGND VPWR VPWR sky130_fd_sc_hd__decap_8
XFILLER_13_229 VPWR VGND VPWR VGND sky130_ef_sc_hd__decap_12
X_702_ _159_ _171_ VGND VGND VPWR VPWR _172_ sky130_fd_sc_hd__nor2_1
X_633_ net29 _102_ _103_ _100_ VGND VGND VPWR VPWR _104_ sky130_fd_sc_hd__a31o_1
XFILLER_12_251 VGND VGND VPWR VPWR sky130_fd_sc_hd__fill_1
X_495_ _412_ _413_ _418_ VGND VGND VPWR VPWR _424_ sky130_fd_sc_hd__a21o_1
X_564_ net55 _033_ VGND VGND VPWR VPWR _035_ sky130_fd_sc_hd__xnor2_1
XFILLER_8_233 VPWR VGND VPWR VGND sky130_ef_sc_hd__decap_12
XFILLER_5_55 VGND VGND VPWR VPWR sky130_fd_sc_hd__fill_1
XFILLER_10_3 VPWR VGND VPWR VGND sky130_ef_sc_hd__decap_12
XFILLER_14_53 VPWR VGND VPWR VGND sky130_ef_sc_hd__decap_12
XFILLER_5_225 VPWR VGND VPWR VGND sky130_ef_sc_hd__decap_12
XFILLER_30_96 VGND VGND VPWR VPWR sky130_fd_sc_hd__decap_8
X_547_ net52 net48 net50 _016_ VGND VGND VPWR VPWR _018_ sky130_fd_sc_hd__or4_1
X_616_ net55 _086_ VGND VGND VPWR VPWR _087_ sky130_fd_sc_hd__and2_1
XFILLER_29_181 VGND VGND VPWR VPWR sky130_fd_sc_hd__decap_8
X_478_ net60 _338_ _306_ net56 VGND VGND VPWR VPWR _403_ sky130_fd_sc_hd__a211oi_2
XFILLER_41_51 VGND VGND VPWR VPWR sky130_fd_sc_hd__decap_4
XFILLER_17_195 VPWR VGND VPWR VGND sky130_ef_sc_hd__decap_12
XTAP_TAPCELL_ROW_19_179 VGND VPWR sky130_fd_sc_hd__tapvpwrvgnd_1
X_881_ net68 net51 _157_ _362_ VGND VGND VPWR VPWR _363_ sky130_fd_sc_hd__o22a_1
XFILLER_36_62 VGND VGND VPWR VPWR sky130_fd_sc_hd__fill_2
Xinput15 op_b[2] VGND VGND VPWR VPWR net15 sky130_fd_sc_hd__clkbuf_1
XFILLER_37_235 VGND VGND VPWR VPWR sky130_fd_sc_hd__fill_1
XTAP_TAPCELL_ROW_15_160 VGND VPWR sky130_fd_sc_hd__tapvpwrvgnd_1
XFILLER_20_113 VPWR VGND VPWR VGND sky130_ef_sc_hd__decap_12
XFILLER_43_249 VGND VGND VPWR VPWR sky130_fd_sc_hd__decap_3
XTAP_TAPCELL_ROW_38_263 VGND VPWR sky130_fd_sc_hd__tapvpwrvgnd_1
XFILLER_11_113 VPWR VGND VPWR VGND sky130_ef_sc_hd__decap_12
X_864_ _339_ _343_ VGND VGND VPWR VPWR _344_ sky130_fd_sc_hd__xor2_1
X_795_ net37 net54 _166_ _174_ net39 VGND VGND VPWR VPWR _270_ sky130_fd_sc_hd__a32o_1
XFILLER_8_77 VGND VGND VPWR VPWR sky130_fd_sc_hd__decap_6
XFILLER_40_3 VPWR VGND VPWR VGND sky130_ef_sc_hd__decap_12
XFILLER_4_109 VPWR VGND VPWR VGND sky130_ef_sc_hd__decap_12
X_580_ _014_ _018_ _049_ VGND VGND VPWR VPWR _051_ sky130_fd_sc_hd__or3_1
XTAP_TAPCELL_ROW_26_211 VGND VPWR sky130_fd_sc_hd__tapvpwrvgnd_1
X_916_ _375_ _399_ VGND VGND VPWR VPWR _400_ sky130_fd_sc_hd__xnor2_1
X_778_ _249_ _250_ VGND VGND VPWR VPWR _251_ sky130_fd_sc_hd__or2_1
X_847_ _310_ _312_ _324_ VGND VGND VPWR VPWR _325_ sky130_fd_sc_hd__a21oi_1
XTAP_TAPCELL_ROW_32_236 VGND VPWR sky130_fd_sc_hd__tapvpwrvgnd_1
XPHY_EDGE_ROW_17_Right_17 VGND VGND VPWR VPWR sky130_fd_sc_hd__decap_3
XPHY_EDGE_ROW_26_Right_26 VGND VGND VPWR VPWR sky130_fd_sc_hd__decap_3
X_701_ net42 net64 VGND VGND VPWR VPWR _171_ sky130_fd_sc_hd__and2_1
X_563_ net55 _033_ VGND VGND VPWR VPWR _034_ sky130_fd_sc_hd__or2_1
XFILLER_28_41 VGND VGND VPWR VPWR sky130_fd_sc_hd__decap_8
X_632_ _087_ _101_ _081_ VGND VGND VPWR VPWR _103_ sky130_fd_sc_hd__o21bai_1
XPHY_EDGE_ROW_35_Right_35 VGND VGND VPWR VPWR sky130_fd_sc_hd__decap_3
XFILLER_8_245 VGND VGND VPWR VPWR sky130_fd_sc_hd__decap_6
X_494_ _413_ _418_ _420_ _411_ VGND VGND VPWR VPWR _423_ sky130_fd_sc_hd__a211o_1
XFILLER_38_171 VPWR VGND VPWR VGND sky130_ef_sc_hd__decap_12
XFILLER_14_65 VPWR VGND VPWR VGND sky130_ef_sc_hd__decap_12
XFILLER_5_237 VPWR VGND VPWR VGND sky130_ef_sc_hd__decap_12
XFILLER_39_51 VGND VGND VPWR VPWR sky130_fd_sc_hd__decap_4
XFILLER_36_119 VGND VGND VPWR VPWR sky130_fd_sc_hd__decap_4
X_546_ net52 net48 net50 _016_ VGND VGND VPWR VPWR _017_ sky130_fd_sc_hd__nor4_1
X_615_ _044_ _085_ _061_ VGND VGND VPWR VPWR _086_ sky130_fd_sc_hd__mux2_1
X_477_ _360_ _370_ _338_ VGND VGND VPWR VPWR _392_ sky130_fd_sc_hd__o21bai_1
XFILLER_26_141 VGND VGND VPWR VPWR sky130_fd_sc_hd__fill_2
XFILLER_17_152 VGND VGND VPWR VPWR sky130_fd_sc_hd__fill_1
XFILLER_17_185 VGND VGND VPWR VPWR sky130_fd_sc_hd__decap_3
X_529_ _438_ _442_ _443_ _456_ VGND VGND VPWR VPWR _000_ sky130_fd_sc_hd__a211o_1
XFILLER_23_100 VGND VGND VPWR VPWR sky130_fd_sc_hd__fill_1
XFILLER_23_111 VGND VGND VPWR VPWR sky130_fd_sc_hd__fill_1
XFILLER_11_55 VGND VGND VPWR VPWR sky130_fd_sc_hd__fill_1
X_880_ net68 net51 _159_ VGND VGND VPWR VPWR _362_ sky130_fd_sc_hd__a21oi_1
XFILLER_36_85 VPWR VGND VPWR VGND sky130_ef_sc_hd__decap_12
XFILLER_14_144 VGND VGND VPWR VPWR sky130_fd_sc_hd__decap_8
Xinput16 op_b[3] VGND VGND VPWR VPWR net16 sky130_fd_sc_hd__clkbuf_1
XFILLER_35_6 VGND VGND VPWR VPWR sky130_fd_sc_hd__decap_4
XFILLER_37_225 VGND VGND VPWR VPWR sky130_fd_sc_hd__decap_4
XTAP_TAPCELL_ROW_15_161 VGND VPWR sky130_fd_sc_hd__tapvpwrvgnd_1
XFILLER_20_125 VGND VGND VPWR VPWR sky130_fd_sc_hd__decap_8
XFILLER_20_158 VPWR VGND VPWR VGND sky130_ef_sc_hd__decap_12
XFILLER_9_181 VPWR VGND VPWR VGND sky130_ef_sc_hd__decap_12
XTAP_TAPCELL_ROW_38_264 VGND VPWR sky130_fd_sc_hd__tapvpwrvgnd_1
XFILLER_11_125 VPWR VGND VPWR VGND sky130_ef_sc_hd__decap_12
XFILLER_11_169 VPWR VGND VPWR VGND sky130_ef_sc_hd__decap_12
XFILLER_0_3 VPWR VGND VPWR VGND sky130_ef_sc_hd__decap_12
X_863_ _341_ _342_ VGND VGND VPWR VPWR _343_ sky130_fd_sc_hd__or2_1
X_794_ net69 _168_ VGND VGND VPWR VPWR _269_ sky130_fd_sc_hd__and2_1
XFILLER_19_225 VPWR VGND VPWR VGND sky130_ef_sc_hd__decap_12
XFILLER_6_195 VGND VGND VPWR VPWR sky130_fd_sc_hd__fill_1
XFILLER_33_3 VPWR VGND VPWR VGND sky130_ef_sc_hd__decap_12
XTAP_TAPCELL_ROW_26_212 VGND VPWR sky130_fd_sc_hd__tapvpwrvgnd_1
X_915_ _376_ _398_ VGND VGND VPWR VPWR _399_ sky130_fd_sc_hd__xnor2_1
X_846_ net68 _322_ VGND VGND VPWR VPWR _324_ sky130_fd_sc_hd__xor2_1
X_777_ net42 net56 net54 net44 VGND VGND VPWR VPWR _250_ sky130_fd_sc_hd__a22oi_1
XTAP_TAPCELL_ROW_32_237 VGND VPWR sky130_fd_sc_hd__tapvpwrvgnd_1
X_700_ _150_ _156_ _170_ VGND VGND VPWR VPWR net21 sky130_fd_sc_hd__or3_1
XFILLER_0_113 VPWR VGND VPWR VGND sky130_ef_sc_hd__decap_12
X_493_ _413_ _418_ _420_ _411_ VGND VGND VPWR VPWR _422_ sky130_fd_sc_hd__a211oi_1
X_562_ _019_ _031_ _032_ VGND VGND VPWR VPWR _033_ sky130_fd_sc_hd__a21oi_2
X_631_ _087_ _101_ _081_ VGND VGND VPWR VPWR _102_ sky130_fd_sc_hd__or3b_1
XFILLER_12_253 VGND VGND VPWR VPWR sky130_fd_sc_hd__fill_2
XFILLER_5_57 VPWR VGND VPWR VGND sky130_ef_sc_hd__decap_12
X_829_ net54 _151_ _160_ VGND VGND VPWR VPWR _307_ sky130_fd_sc_hd__o21a_1
XFILLER_38_183 VPWR VGND VPWR VGND sky130_ef_sc_hd__decap_12
XFILLER_14_77 VGND VGND VPWR VPWR sky130_fd_sc_hd__decap_6
XFILLER_5_249 VGND VGND VPWR VPWR sky130_fd_sc_hd__decap_8
XFILLER_5_205 VPWR VGND VPWR VGND sky130_ef_sc_hd__decap_12
X_545_ net55 _440_ _012_ VGND VGND VPWR VPWR _016_ sky130_fd_sc_hd__and3_1
X_614_ _048_ _084_ VGND VGND VPWR VPWR _085_ sky130_fd_sc_hd__xnor2_1
X_476_ net62 _349_ VGND VGND VPWR VPWR _381_ sky130_fd_sc_hd__or2_1
XFILLER_25_65 VGND VGND VPWR VPWR sky130_fd_sc_hd__decap_3
XFILLER_41_75 VGND VGND VPWR VPWR sky130_fd_sc_hd__fill_1
X_459_ net3 VGND VGND VPWR VPWR _199_ sky130_fd_sc_hd__inv_2
X_528_ _414_ _455_ VGND VGND VPWR VPWR _457_ sky130_fd_sc_hd__nand2_1
XFILLER_36_20 VGND VGND VPWR VPWR sky130_fd_sc_hd__decap_8
XFILLER_36_97 VGND VGND VPWR VPWR sky130_fd_sc_hd__decap_4
Xinput17 op_b[4] VGND VGND VPWR VPWR net17 sky130_fd_sc_hd__clkbuf_2
XFILLER_37_248 VGND VGND VPWR VPWR sky130_fd_sc_hd__decap_8
XFILLER_9_193 VPWR VGND VPWR VGND sky130_ef_sc_hd__decap_12
XTAP_TAPCELL_ROW_15_162 VGND VPWR sky130_fd_sc_hd__tapvpwrvgnd_1
XFILLER_20_104 VGND VGND VPWR VPWR sky130_fd_sc_hd__fill_1
XTAP_TAPCELL_ROW_38_265 VGND VPWR sky130_fd_sc_hd__tapvpwrvgnd_1
XFILLER_11_137 VPWR VGND VPWR VGND sky130_ef_sc_hd__decap_12
XTAP_TAPCELL_ROW_21_187 VGND VPWR sky130_fd_sc_hd__tapvpwrvgnd_1
X_862_ net13 net67 net63 net69 VGND VGND VPWR VPWR _342_ sky130_fd_sc_hd__a22oi_1
XFILLER_19_237 VPWR VGND VPWR VGND sky130_ef_sc_hd__decap_12
X_793_ net37 net54 _157_ _267_ VGND VGND VPWR VPWR _268_ sky130_fd_sc_hd__o22a_1
XFILLER_42_240 VGND VGND VPWR VPWR sky130_fd_sc_hd__fill_2
XFILLER_6_141 VPWR VGND VPWR VGND sky130_ef_sc_hd__decap_12
XFILLER_25_229 VGND VGND VPWR VPWR sky130_fd_sc_hd__fill_1
XFILLER_33_240 VPWR VGND VPWR VGND sky130_ef_sc_hd__decap_12
XTAP_TAPCELL_ROW_43_290 VGND VPWR sky130_fd_sc_hd__tapvpwrvgnd_1
XTAP_TAPCELL_ROW_26_213 VGND VPWR sky130_fd_sc_hd__tapvpwrvgnd_1
XFILLER_3_111 VGND VGND VPWR VPWR sky130_fd_sc_hd__fill_1
X_914_ _394_ _397_ VGND VGND VPWR VPWR _398_ sky130_fd_sc_hd__xnor2_1
X_776_ net44 net42 net56 net54 VGND VGND VPWR VPWR _249_ sky130_fd_sc_hd__and4_1
X_845_ _322_ VGND VGND VPWR VPWR _323_ sky130_fd_sc_hd__inv_2
XTAP_TAPCELL_ROW_32_238 VGND VPWR sky130_fd_sc_hd__tapvpwrvgnd_1
XPHY_EDGE_ROW_29_Left_73 VGND VGND VPWR VPWR sky130_fd_sc_hd__decap_3
XPHY_EDGE_ROW_13_Left_57 VGND VGND VPWR VPWR sky130_fd_sc_hd__decap_3
XPHY_EDGE_ROW_3_Right_3 VGND VGND VPWR VPWR sky130_fd_sc_hd__decap_3
XFILLER_0_125 VPWR VGND VPWR VGND sky130_ef_sc_hd__decap_12
XFILLER_0_169 VPWR VGND VPWR VGND sky130_ef_sc_hd__decap_12
X_630_ _069_ _079_ _092_ _094_ VGND VGND VPWR VPWR _101_ sky130_fd_sc_hd__o31a_1
XFILLER_12_221 VPWR VGND VPWR VGND sky130_ef_sc_hd__decap_12
X_561_ _015_ net31 _446_ VGND VGND VPWR VPWR _032_ sky130_fd_sc_hd__a21oi_1
X_492_ net59 _392_ VGND VGND VPWR VPWR _421_ sky130_fd_sc_hd__or2_1
XFILLER_5_69 VPWR VGND VPWR VGND sky130_ef_sc_hd__decap_12
X_759_ net45 net57 _230_ VGND VGND VPWR VPWR _232_ sky130_fd_sc_hd__and3_1
X_828_ net37 _245_ _248_ VGND VGND VPWR VPWR _305_ sky130_fd_sc_hd__a21o_1
XFILLER_38_195 VGND VGND VPWR VPWR sky130_fd_sc_hd__fill_1
XFILLER_5_217 VGND VGND VPWR VPWR sky130_fd_sc_hd__decap_6
XFILLER_30_55 VPWR VGND VPWR VGND sky130_ef_sc_hd__decap_12
X_613_ _030_ _055_ _053_ VGND VGND VPWR VPWR _084_ sky130_fd_sc_hd__a21o_1
X_544_ _448_ _454_ _010_ _013_ _447_ VGND VGND VPWR VPWR _015_ sky130_fd_sc_hd__a311o_1
X_475_ net62 _349_ VGND VGND VPWR VPWR _370_ sky130_fd_sc_hd__nor2_1
XFILLER_2_209 VPWR VGND VPWR VGND sky130_ef_sc_hd__decap_12
XPHY_EDGE_ROW_16_Left_60 VGND VGND VPWR VPWR sky130_fd_sc_hd__decap_3
XFILLER_25_55 VGND VGND VPWR VPWR sky130_fd_sc_hd__fill_1
XFILLER_2_15 VPWR VGND VPWR VGND sky130_ef_sc_hd__decap_12
XFILLER_17_121 VGND VGND VPWR VPWR sky130_fd_sc_hd__decap_3
X_527_ _414_ _455_ VGND VGND VPWR VPWR _456_ sky130_fd_sc_hd__and2_1
X_458_ net65 VGND VGND VPWR VPWR _188_ sky130_fd_sc_hd__inv_2
XFILLER_23_113 VGND VGND VPWR VPWR sky130_fd_sc_hd__fill_2
XFILLER_11_57 VPWR VGND VPWR VGND sky130_ef_sc_hd__decap_12
XPHY_EDGE_ROW_1_Left_45 VGND VGND VPWR VPWR sky130_fd_sc_hd__decap_3
XFILLER_14_168 VPWR VGND VPWR VGND sky130_ef_sc_hd__decap_12
Xinput18 op_b[5] VGND VGND VPWR VPWR net18 sky130_fd_sc_hd__buf_1
XFILLER_37_205 VPWR VGND VPWR VGND sky130_ef_sc_hd__decap_12
XFILLER_9_161 VGND VGND VPWR VPWR sky130_fd_sc_hd__decap_6
XTAP_TAPCELL_ROW_15_163 VGND VPWR sky130_fd_sc_hd__tapvpwrvgnd_1
XPHY_EDGE_ROW_43_Left_87 VGND VGND VPWR VPWR sky130_fd_sc_hd__decap_3
XTAP_TAPCELL_ROW_38_266 VGND VPWR sky130_fd_sc_hd__tapvpwrvgnd_1
XFILLER_11_105 VGND VGND VPWR VPWR sky130_fd_sc_hd__decap_6
XFILLER_11_149 VPWR VGND VPWR VGND sky130_ef_sc_hd__decap_12
XTAP_TAPCELL_ROW_21_188 VGND VPWR sky130_fd_sc_hd__tapvpwrvgnd_1
X_792_ net37 net54 _159_ VGND VGND VPWR VPWR _267_ sky130_fd_sc_hd__a21oi_1
XTAP_TAPCELL_ROW_6_120 VGND VPWR sky130_fd_sc_hd__tapvpwrvgnd_1
X_861_ net67 net63 _417_ VGND VGND VPWR VPWR _341_ sky130_fd_sc_hd__and3_1
XFILLER_6_153 VPWR VGND VPWR VGND sky130_ef_sc_hd__decap_12
XFILLER_6_197 VPWR VGND VPWR VGND sky130_ef_sc_hd__decap_12
XFILLER_19_3 VPWR VGND VPWR VGND sky130_ef_sc_hd__decap_12
XFILLER_25_208 VGND VGND VPWR VPWR sky130_fd_sc_hd__decap_8
XTAP_TAPCELL_ROW_43_291 VGND VPWR sky130_fd_sc_hd__tapvpwrvgnd_1
XFILLER_33_252 VGND VGND VPWR VPWR sky130_fd_sc_hd__decap_6
XFILLER_33_55 VGND VGND VPWR VPWR sky130_fd_sc_hd__fill_1
XFILLER_3_167 VGND VGND VPWR VPWR sky130_fd_sc_hd__fill_1
X_913_ _395_ _396_ VGND VGND VPWR VPWR _397_ sky130_fd_sc_hd__xnor2_1
X_775_ _216_ _219_ _246_ VGND VGND VPWR VPWR _248_ sky130_fd_sc_hd__a21oi_1
X_844_ net50 _321_ VGND VGND VPWR VPWR _322_ sky130_fd_sc_hd__xor2_1
XFILLER_15_230 VPWR VGND VPWR VGND sky130_ef_sc_hd__decap_12
XTAP_TAPCELL_ROW_32_239 VGND VPWR sky130_fd_sc_hd__tapvpwrvgnd_1
XTAP_TAPCELL_ROW_40_272 VGND VPWR sky130_fd_sc_hd__tapvpwrvgnd_1
XFILLER_0_81 VGND VGND VPWR VPWR sky130_fd_sc_hd__decap_3
XFILLER_21_222 VGND VGND VPWR VPWR sky130_fd_sc_hd__fill_2
XFILLER_21_255 VGND VGND VPWR VPWR sky130_fd_sc_hd__decap_4
XFILLER_0_137 VGND VGND VPWR VPWR sky130_fd_sc_hd__decap_3
X_560_ _448_ _011_ VGND VGND VPWR VPWR _031_ sky130_fd_sc_hd__xnor2_1
XFILLER_12_233 VPWR VGND VPWR VGND sky130_ef_sc_hd__decap_12
X_491_ net59 _392_ VGND VGND VPWR VPWR _420_ sky130_fd_sc_hd__nor2_1
XFILLER_5_15 VPWR VGND VPWR VGND sky130_ef_sc_hd__decap_12
XPHY_EDGE_ROW_30_Left_74 VGND VGND VPWR VPWR sky130_fd_sc_hd__decap_3
X_689_ net1 net3 net47 net2 VGND VGND VPWR VPWR _160_ sky130_fd_sc_hd__or4b_4
X_758_ _222_ _228_ VGND VGND VPWR VPWR _230_ sky130_fd_sc_hd__xnor2_1
XPHY_EDGE_ROW_13_Right_13 VGND VGND VPWR VPWR sky130_fd_sc_hd__decap_3
X_827_ _266_ _301_ net32 VGND VGND VPWR VPWR _304_ sky130_fd_sc_hd__o21a_1
XPHY_EDGE_ROW_22_Right_22 VGND VGND VPWR VPWR sky130_fd_sc_hd__decap_3
XFILLER_38_141 VPWR VGND VPWR VGND sky130_ef_sc_hd__decap_12
XPHY_EDGE_ROW_31_Right_31 VGND VGND VPWR VPWR sky130_fd_sc_hd__decap_3
XPHY_EDGE_ROW_40_Right_40 VGND VGND VPWR VPWR sky130_fd_sc_hd__decap_3
XFILLER_30_67 VGND VGND VPWR VPWR sky130_fd_sc_hd__decap_4
XFILLER_30_78 VGND VGND VPWR VPWR sky130_fd_sc_hd__decap_6
X_543_ _448_ _454_ _010_ _013_ _447_ VGND VGND VPWR VPWR _014_ sky130_fd_sc_hd__a311oi_2
X_612_ net50 _082_ VGND VGND VPWR VPWR _083_ sky130_fd_sc_hd__xnor2_1
X_474_ net62 _349_ _317_ _306_ VGND VGND VPWR VPWR _360_ sky130_fd_sc_hd__a211o_1
XFILLER_4_251 VGND VGND VPWR VPWR sky130_fd_sc_hd__fill_1
XFILLER_35_111 VGND VGND VPWR VPWR sky130_fd_sc_hd__fill_1
XFILLER_35_122 VGND VGND VPWR VPWR sky130_fd_sc_hd__decap_8
XFILLER_35_144 VGND VGND VPWR VPWR sky130_fd_sc_hd__decap_3
XFILLER_26_133 VGND VGND VPWR VPWR sky130_fd_sc_hd__decap_3
XFILLER_41_55 VGND VGND VPWR VPWR sky130_fd_sc_hd__fill_1
XFILLER_2_27 VGND VGND VPWR VPWR sky130_fd_sc_hd__fill_1
X_526_ net65 net36 VGND VGND VPWR VPWR _455_ sky130_fd_sc_hd__nand2_1
XFILLER_17_144 VGND VGND VPWR VPWR sky130_fd_sc_hd__decap_8
XFILLER_17_166 VGND VGND VPWR VPWR sky130_fd_sc_hd__fill_2
XFILLER_17_177 VGND VGND VPWR VPWR sky130_fd_sc_hd__decap_8
XFILLER_32_103 VPWR VGND VPWR VGND sky130_ef_sc_hd__decap_12
XFILLER_40_191 VGND VGND VPWR VPWR sky130_fd_sc_hd__decap_4
XFILLER_23_147 VPWR VGND VPWR VGND sky130_ef_sc_hd__decap_12
XFILLER_23_169 VPWR VGND VPWR VGND sky130_ef_sc_hd__decap_12
XFILLER_11_69 VPWR VGND VPWR VGND sky130_ef_sc_hd__decap_12
Xinput19 op_b[6] VGND VGND VPWR VPWR net19 sky130_fd_sc_hd__buf_1
XFILLER_37_217 VGND VGND VPWR VPWR sky130_fd_sc_hd__decap_6
X_509_ _435_ _436_ _428_ _429_ VGND VGND VPWR VPWR _438_ sky130_fd_sc_hd__a211o_1
XFILLER_3_81 VPWR VGND VPWR VGND sky130_ef_sc_hd__decap_12
XTAP_TAPCELL_ROW_38_267 VGND VPWR sky130_fd_sc_hd__tapvpwrvgnd_1
XFILLER_28_228 VGND VGND VPWR VPWR sky130_fd_sc_hd__fill_1
XFILLER_28_239 VPWR VGND VPWR VGND sky130_ef_sc_hd__decap_12
XFILLER_22_35 VGND VGND VPWR VPWR sky130_fd_sc_hd__fill_1
XTAP_TAPCELL_ROW_21_189 VGND VPWR sky130_fd_sc_hd__tapvpwrvgnd_1
XFILLER_22_79 VGND VGND VPWR VPWR sky130_fd_sc_hd__fill_1
X_791_ _235_ _264_ VGND VGND VPWR VPWR _266_ sky130_fd_sc_hd__nand2_1
XTAP_TAPCELL_ROW_6_121 VGND VPWR sky130_fd_sc_hd__tapvpwrvgnd_1
X_860_ net67 net62 VGND VGND VPWR VPWR _340_ sky130_fd_sc_hd__nand2_1
XTAP_TAPCELL_ROW_29_223 VGND VPWR sky130_fd_sc_hd__tapvpwrvgnd_1
XFILLER_8_15 VPWR VGND VPWR VGND sky130_ef_sc_hd__decap_12
XFILLER_6_165 VPWR VGND VPWR VGND sky130_ef_sc_hd__decap_12
XFILLER_6_121 VPWR VGND VPWR VGND sky130_ef_sc_hd__decap_12
XTAP_TAPCELL_ROW_43_292 VGND VPWR sky130_fd_sc_hd__tapvpwrvgnd_1
XFILLER_16_209 VPWR VGND VPWR VGND sky130_ef_sc_hd__decap_12
XFILLER_17_68 VPWR VGND VPWR VGND sky130_ef_sc_hd__decap_12
XFILLER_33_78 VGND VGND VPWR VPWR sky130_fd_sc_hd__decap_4
XFILLER_3_113 VPWR VGND VPWR VGND sky130_ef_sc_hd__decap_12
X_912_ _337_ _348_ _346_ VGND VGND VPWR VPWR _396_ sky130_fd_sc_hd__a21oi_1
X_843_ net53 _160_ _307_ VGND VGND VPWR VPWR _321_ sky130_fd_sc_hd__a21o_1
X_774_ _216_ _219_ _246_ VGND VGND VPWR VPWR _247_ sky130_fd_sc_hd__and3_1
XFILLER_15_242 VPWR VGND VPWR VGND sky130_ef_sc_hd__decap_12
XTAP_TAPCELL_ROW_40_273 VGND VPWR sky130_fd_sc_hd__tapvpwrvgnd_1
XFILLER_28_78 VGND VGND VPWR VPWR sky130_fd_sc_hd__decap_6
XFILLER_12_245 VGND VGND VPWR VPWR sky130_fd_sc_hd__decap_6
X_490_ _412_ _413_ _418_ VGND VGND VPWR VPWR _419_ sky130_fd_sc_hd__nand3_1
XFILLER_5_27 VPWR VGND VPWR VGND sky130_ef_sc_hd__decap_12
X_826_ _266_ _301_ VGND VGND VPWR VPWR _303_ sky130_fd_sc_hd__nor2_1
X_688_ _158_ net3 net47 VGND VGND VPWR VPWR _159_ sky130_fd_sc_hd__or3b_4
X_757_ _222_ _228_ VGND VGND VPWR VPWR _229_ sky130_fd_sc_hd__and2b_1
XFILLER_38_197 VGND VGND VPWR VPWR sky130_fd_sc_hd__decap_4
XFILLER_38_153 VPWR VGND VPWR VGND sky130_ef_sc_hd__decap_12
XFILLER_39_77 VGND VGND VPWR VPWR sky130_fd_sc_hd__fill_1
XFILLER_39_55 VGND VGND VPWR VPWR sky130_fd_sc_hd__fill_1
X_542_ _440_ _012_ net55 VGND VGND VPWR VPWR _013_ sky130_fd_sc_hd__a21oi_1
X_473_ net67 net65 VGND VGND VPWR VPWR _349_ sky130_fd_sc_hd__and2b_1
X_611_ _036_ _061_ _440_ VGND VGND VPWR VPWR _082_ sky130_fd_sc_hd__o21ai_1
X_809_ _282_ _283_ _281_ VGND VGND VPWR VPWR _285_ sky130_fd_sc_hd__o21a_1
XFILLER_35_167 VGND VGND VPWR VPWR sky130_fd_sc_hd__fill_1
XFILLER_25_57 VGND VGND VPWR VPWR sky130_fd_sc_hd__decap_8
XFILLER_9_3 VPWR VGND VPWR VGND sky130_ef_sc_hd__decap_12
X_525_ net59 _452_ VGND VGND VPWR VPWR _454_ sky130_fd_sc_hd__nand2_1
XFILLER_32_115 VGND VGND VPWR VPWR sky130_fd_sc_hd__decap_8
XFILLER_32_126 VGND VGND VPWR VPWR sky130_fd_sc_hd__decap_4
XFILLER_32_148 VPWR VGND VPWR VGND sky130_ef_sc_hd__decap_12
XTAP_TAPCELL_ROW_18_173 VGND VPWR sky130_fd_sc_hd__tapvpwrvgnd_1
XFILLER_23_137 VGND VGND VPWR VPWR sky130_fd_sc_hd__decap_4
XFILLER_23_159 VGND VGND VPWR VPWR sky130_fd_sc_hd__fill_1
XFILLER_11_15 VPWR VGND VPWR VGND sky130_ef_sc_hd__decap_12
XFILLER_22_181 VGND VGND VPWR VPWR sky130_fd_sc_hd__decap_8
XFILLER_37_229 VGND VGND VPWR VPWR sky130_fd_sc_hd__fill_1
XFILLER_13_181 VGND VGND VPWR VPWR sky130_fd_sc_hd__fill_2
X_508_ _435_ _436_ VGND VGND VPWR VPWR _437_ sky130_fd_sc_hd__nand2_1
XFILLER_3_93 VPWR VGND VPWR VGND sky130_ef_sc_hd__decap_12
Xwire33 _327_ VGND VGND VPWR VPWR net33 sky130_fd_sc_hd__clkbuf_1
XTAP_TAPCELL_ROW_6_122 VGND VPWR sky130_fd_sc_hd__tapvpwrvgnd_1
X_790_ _235_ _264_ VGND VGND VPWR VPWR _265_ sky130_fd_sc_hd__or2_1
XTAP_TAPCELL_ROW_29_224 VGND VPWR sky130_fd_sc_hd__tapvpwrvgnd_1
XFILLER_8_27 VGND VGND VPWR VPWR sky130_fd_sc_hd__fill_1
XFILLER_10_195 VGND VGND VPWR VPWR sky130_fd_sc_hd__fill_1
XFILLER_6_177 VPWR VGND VPWR VGND sky130_ef_sc_hd__decap_12
XFILLER_6_133 VGND VGND VPWR VPWR sky130_fd_sc_hd__decap_6
XTAP_TAPCELL_ROW_12_146 VGND VPWR sky130_fd_sc_hd__tapvpwrvgnd_1
XFILLER_26_6 VGND VGND VPWR VPWR sky130_fd_sc_hd__decap_6
XTAP_TAPCELL_ROW_43_293 VGND VPWR sky130_fd_sc_hd__tapvpwrvgnd_1
XFILLER_17_47 VGND VGND VPWR VPWR sky130_fd_sc_hd__decap_3
XFILLER_33_35 VPWR VGND VPWR VGND sky130_ef_sc_hd__decap_12
XFILLER_33_57 VPWR VGND VPWR VGND sky130_ef_sc_hd__decap_12
XFILLER_3_125 VPWR VGND VPWR VGND sky130_ef_sc_hd__decap_12
XFILLER_3_169 VPWR VGND VPWR VGND sky130_ef_sc_hd__decap_12
X_911_ net42 net53 _336_ _335_ VGND VGND VPWR VPWR _395_ sky130_fd_sc_hd__a31o_1
X_842_ _318_ _319_ _320_ VGND VGND VPWR VPWR net26 sky130_fd_sc_hd__or3_1
X_773_ net37 _245_ VGND VGND VPWR VPWR _246_ sky130_fd_sc_hd__xnor2_1
XFILLER_15_221 VGND VGND VPWR VPWR sky130_fd_sc_hd__decap_3
XTAP_TAPCELL_ROW_40_274 VGND VPWR sky130_fd_sc_hd__tapvpwrvgnd_1
XFILLER_15_254 VGND VGND VPWR VPWR sky130_fd_sc_hd__fill_1
XFILLER_30_224 VPWR VGND VPWR VGND sky130_ef_sc_hd__decap_12
XFILLER_24_3 VGND VGND VPWR VPWR sky130_fd_sc_hd__decap_3
XFILLER_21_202 VGND VGND VPWR VPWR sky130_fd_sc_hd__decap_3
XFILLER_9_81 VPWR VGND VPWR VGND sky130_ef_sc_hd__decap_12
XFILLER_5_39 VPWR VGND VPWR VGND sky130_ef_sc_hd__decap_12
X_756_ _223_ _227_ VGND VGND VPWR VPWR _228_ sky130_fd_sc_hd__xnor2_1
X_825_ _266_ _301_ VGND VGND VPWR VPWR _302_ sky130_fd_sc_hd__nand2_1
X_687_ net1 net2 VGND VGND VPWR VPWR _158_ sky130_fd_sc_hd__nand2_1
XPHY_EDGE_ROW_7_Right_7 VGND VGND VPWR VPWR sky130_fd_sc_hd__decap_3
XFILLER_38_165 VGND VGND VPWR VPWR sky130_fd_sc_hd__fill_1
XFILLER_14_15 VPWR VGND VPWR VGND sky130_ef_sc_hd__decap_12
XFILLER_29_143 VPWR VGND VPWR VGND sky130_ef_sc_hd__decap_12
X_610_ net52 _064_ VGND VGND VPWR VPWR _081_ sky130_fd_sc_hd__xor2_1
X_541_ _439_ _444_ VGND VGND VPWR VPWR _012_ sky130_fd_sc_hd__or2_1
X_472_ net35 net63 _317_ _306_ net12 VGND VGND VPWR VPWR _338_ sky130_fd_sc_hd__o41ai_4
XFILLER_29_198 VGND VGND VPWR VPWR sky130_fd_sc_hd__decap_8
XFILLER_4_253 VGND VGND VPWR VPWR sky130_fd_sc_hd__decap_6
X_739_ net43 _174_ _205_ net32 _208_ VGND VGND VPWR VPWR _211_ sky130_fd_sc_hd__a221o_1
X_808_ net36 net63 _417_ VGND VGND VPWR VPWR _283_ sky130_fd_sc_hd__a21oi_1
XFILLER_41_57 VPWR VGND VPWR VGND sky130_ef_sc_hd__decap_12
XFILLER_1_223 VGND VGND VPWR VPWR sky130_fd_sc_hd__fill_1
XFILLER_2_29 VPWR VGND VPWR VGND sky130_ef_sc_hd__decap_12
X_524_ _433_ _451_ _444_ VGND VGND VPWR VPWR _453_ sky130_fd_sc_hd__mux2_1
XTAP_TAPCELL_ROW_18_174 VGND VPWR sky130_fd_sc_hd__tapvpwrvgnd_1
XFILLER_31_193 VPWR VGND VPWR VGND sky130_ef_sc_hd__decap_12
XFILLER_11_27 VPWR VGND VPWR VGND sky130_ef_sc_hd__decap_12
XFILLER_14_138 VGND VGND VPWR VPWR sky130_fd_sc_hd__fill_2
X_507_ net62 _431_ _432_ _415_ VGND VGND VPWR VPWR _436_ sky130_fd_sc_hd__a31o_1
Xrebuffer1 _338_ VGND VGND VPWR VPWR net70 sky130_fd_sc_hd__dlygate4sd1_1
XPHY_EDGE_ROW_5_Left_49 VGND VGND VPWR VPWR sky130_fd_sc_hd__decap_3
XFILLER_22_26 VGND VGND VPWR VPWR sky130_fd_sc_hd__fill_2
XFILLER_22_59 VPWR VGND VPWR VGND sky130_ef_sc_hd__decap_12
XTAP_TAPCELL_ROW_6_123 VGND VPWR sky130_fd_sc_hd__tapvpwrvgnd_1
XFILLER_19_219 VGND VGND VPWR VPWR sky130_fd_sc_hd__decap_4
XTAP_TAPCELL_ROW_29_225 VGND VPWR sky130_fd_sc_hd__tapvpwrvgnd_1
XFILLER_10_141 VPWR VGND VPWR VGND sky130_ef_sc_hd__decap_12
XTAP_TAPCELL_ROW_12_147 VGND VPWR sky130_fd_sc_hd__tapvpwrvgnd_1
XFILLER_6_189 VGND VGND VPWR VPWR sky130_fd_sc_hd__decap_6
XFILLER_33_233 VGND VGND VPWR VPWR sky130_fd_sc_hd__fill_1
XTAP_TAPCELL_ROW_43_294 VGND VPWR sky130_fd_sc_hd__tapvpwrvgnd_1
XFILLER_17_15 VPWR VGND VPWR VGND sky130_ef_sc_hd__decap_12
XFILLER_24_222 VGND VGND VPWR VPWR sky130_fd_sc_hd__decap_3
XFILLER_33_47 VGND VGND VPWR VPWR sky130_fd_sc_hd__decap_8
XFILLER_33_69 VGND VGND VPWR VPWR sky130_fd_sc_hd__fill_1
XFILLER_3_137 VPWR VGND VPWR VGND sky130_ef_sc_hd__decap_12
X_910_ _386_ _393_ VGND VGND VPWR VPWR _394_ sky130_fd_sc_hd__xnor2_1
X_841_ _295_ _403_ _423_ _314_ VGND VGND VPWR VPWR _320_ sky130_fd_sc_hd__a31o_1
X_772_ net54 _244_ VGND VGND VPWR VPWR _245_ sky130_fd_sc_hd__xor2_1
XFILLER_15_211 VGND VGND VPWR VPWR sky130_fd_sc_hd__fill_2
XTAP_TAPCELL_ROW_40_275 VGND VPWR sky130_fd_sc_hd__tapvpwrvgnd_1
XFILLER_30_236 VGND VGND VPWR VPWR sky130_fd_sc_hd__decap_6
XFILLER_30_258 VGND VGND VPWR VPWR sky130_fd_sc_hd__fill_1
XFILLER_17_3 VPWR VGND VPWR VGND sky130_ef_sc_hd__decap_12
XFILLER_21_214 VGND VGND VPWR VPWR sky130_fd_sc_hd__decap_8
XFILLER_21_225 VGND VGND VPWR VPWR sky130_fd_sc_hd__fill_2
XFILLER_9_93 VPWR VGND VPWR VGND sky130_ef_sc_hd__decap_12
XPHY_EDGE_ROW_8_Left_52 VGND VGND VPWR VPWR sky130_fd_sc_hd__decap_3
X_755_ _225_ _226_ VGND VGND VPWR VPWR _227_ sky130_fd_sc_hd__nor2_1
X_824_ _298_ _300_ VGND VGND VPWR VPWR _301_ sky130_fd_sc_hd__nand2_1
X_686_ net1 net2 _199_ net47 VGND VGND VPWR VPWR _157_ sky130_fd_sc_hd__and4b_2
XFILLER_14_27 VGND VGND VPWR VPWR sky130_fd_sc_hd__fill_1
XFILLER_39_57 VPWR VGND VPWR VGND sky130_ef_sc_hd__decap_12
X_540_ _454_ _010_ VGND VGND VPWR VPWR _011_ sky130_fd_sc_hd__nand2_1
XFILLER_29_111 VGND VGND VPWR VPWR sky130_fd_sc_hd__fill_1
XFILLER_29_155 VPWR VGND VPWR VGND sky130_ef_sc_hd__decap_12
XPHY_EDGE_ROW_34_Left_78 VGND VGND VPWR VPWR sky130_fd_sc_hd__decap_3
X_471_ net66 _231_ net63 _306_ _317_ VGND VGND VPWR VPWR _327_ sky130_fd_sc_hd__a2111oi_1
XFILLER_4_221 VPWR VGND VPWR VGND sky130_ef_sc_hd__decap_12
X_738_ net41 net61 _166_ _168_ net38 VGND VGND VPWR VPWR _209_ sky130_fd_sc_hd__a32o_1
XFILLER_35_169 VGND VGND VPWR VPWR sky130_fd_sc_hd__decap_3
X_807_ net36 net63 _417_ VGND VGND VPWR VPWR _282_ sky130_fd_sc_hd__and3_1
X_669_ net34 _136_ _139_ VGND VGND VPWR VPWR _140_ sky130_fd_sc_hd__a21o_1
XFILLER_35_136 VGND VGND VPWR VPWR sky130_fd_sc_hd__decap_8
XFILLER_6_83 VGND VGND VPWR VPWR sky130_fd_sc_hd__fill_1
XFILLER_26_114 VGND VGND VPWR VPWR sky130_fd_sc_hd__decap_8
XFILLER_26_125 VGND VGND VPWR VPWR sky130_fd_sc_hd__decap_8
XFILLER_41_69 VGND VGND VPWR VPWR sky130_fd_sc_hd__decap_6
XFILLER_1_257 VGND VGND VPWR VPWR sky130_fd_sc_hd__fill_2
X_523_ _434_ _450_ _444_ VGND VGND VPWR VPWR _452_ sky130_fd_sc_hd__mux2_1
XFILLER_15_81 VPWR VGND VPWR VGND sky130_ef_sc_hd__decap_12
XFILLER_25_180 VGND VGND VPWR VPWR sky130_fd_sc_hd__decap_8
XTAP_TAPCELL_ROW_18_175 VGND VPWR sky130_fd_sc_hd__tapvpwrvgnd_1
XFILLER_23_128 VGND VGND VPWR VPWR sky130_fd_sc_hd__decap_4
XFILLER_11_39 VPWR VGND VPWR VGND sky130_ef_sc_hd__decap_12
XFILLER_36_14 VGND VGND VPWR VPWR sky130_fd_sc_hd__fill_2
XPHY_EDGE_ROW_37_Left_81 VGND VGND VPWR VPWR sky130_fd_sc_hd__decap_3
X_506_ _431_ _432_ net62 VGND VGND VPWR VPWR _435_ sky130_fd_sc_hd__a21o_1
XFILLER_26_80 VGND VGND VPWR VPWR sky130_fd_sc_hd__decap_4
XFILLER_13_161 VGND VGND VPWR VPWR sky130_fd_sc_hd__decap_6
XFILLER_13_194 VPWR VGND VPWR VGND sky130_ef_sc_hd__decap_12
XPHY_EDGE_ROW_21_Left_65 VGND VGND VPWR VPWR sky130_fd_sc_hd__decap_3
XFILLER_36_253 VGND VGND VPWR VPWR sky130_fd_sc_hd__decap_6
XFILLER_3_51 VGND VGND VPWR VPWR sky130_fd_sc_hd__decap_4
XFILLER_42_245 VGND VGND VPWR VPWR sky130_fd_sc_hd__fill_2
XTAP_TAPCELL_ROW_29_226 VGND VPWR sky130_fd_sc_hd__tapvpwrvgnd_1
XPHY_EDGE_ROW_29_Right_29 VGND VGND VPWR VPWR sky130_fd_sc_hd__decap_3
XFILLER_42_256 VGND VGND VPWR VPWR sky130_fd_sc_hd__decap_3
XPHY_EDGE_ROW_38_Right_38 VGND VGND VPWR VPWR sky130_fd_sc_hd__decap_3
XFILLER_10_153 VPWR VGND VPWR VGND sky130_ef_sc_hd__decap_12
XFILLER_8_29 VPWR VGND VPWR VGND sky130_ef_sc_hd__decap_12
XTAP_TAPCELL_ROW_12_148 VGND VPWR sky130_fd_sc_hd__tapvpwrvgnd_1
XFILLER_10_197 VPWR VGND VPWR VGND sky130_ef_sc_hd__decap_12
XFILLER_18_253 VGND VGND VPWR VPWR sky130_fd_sc_hd__decap_6
XFILLER_33_223 VGND VGND VPWR VPWR sky130_fd_sc_hd__fill_1
XFILLER_17_27 VPWR VGND VPWR VGND sky130_ef_sc_hd__decap_12
XFILLER_24_201 VGND VGND VPWR VPWR sky130_fd_sc_hd__decap_4
XFILLER_24_256 VGND VGND VPWR VPWR sky130_fd_sc_hd__decap_3
XFILLER_33_15 VPWR VGND VPWR VGND sky130_ef_sc_hd__decap_12
XFILLER_3_149 VPWR VGND VPWR VGND sky130_ef_sc_hd__decap_12
XFILLER_3_105 VGND VGND VPWR VPWR sky130_fd_sc_hd__decap_6
X_771_ _151_ _160_ VGND VGND VPWR VPWR _244_ sky130_fd_sc_hd__nand2_1
X_840_ net37 _174_ _302_ _304_ _316_ VGND VGND VPWR VPWR _319_ sky130_fd_sc_hd__a221o_1
XTAP_TAPCELL_ROW_40_276 VGND VPWR sky130_fd_sc_hd__tapvpwrvgnd_1
XFILLER_0_41 VPWR VGND VPWR VGND sky130_ef_sc_hd__decap_12
XFILLER_0_85 VPWR VGND VPWR VGND sky130_ef_sc_hd__decap_12
XTAP_TAPCELL_ROW_31_232 VGND VPWR sky130_fd_sc_hd__tapvpwrvgnd_1
XFILLER_28_15 VPWR VGND VPWR VGND sky130_ef_sc_hd__decap_12
X_823_ _261_ _297_ VGND VGND VPWR VPWR _300_ sky130_fd_sc_hd__nand2_1
X_685_ _152_ _155_ _199_ net47 _284_ VGND VGND VPWR VPWR _156_ sky130_fd_sc_hd__o2111a_1
X_754_ net40 net63 _007_ VGND VGND VPWR VPWR _226_ sky130_fd_sc_hd__a21oi_1
XFILLER_30_27 VGND VGND VPWR VPWR sky130_fd_sc_hd__fill_1
XFILLER_39_69 VGND VGND VPWR VPWR sky130_fd_sc_hd__decap_8
XFILLER_29_167 VGND VGND VPWR VPWR sky130_fd_sc_hd__fill_1
XFILLER_29_189 VGND VGND VPWR VPWR sky130_fd_sc_hd__fill_2
X_470_ net56 net60 VGND VGND VPWR VPWR _317_ sky130_fd_sc_hd__or2_2
XFILLER_4_233 VPWR VGND VPWR VGND sky130_ef_sc_hd__decap_12
X_806_ net38 net60 VGND VGND VPWR VPWR _281_ sky130_fd_sc_hd__nand2_1
X_737_ net7 net61 _157_ _207_ VGND VGND VPWR VPWR _208_ sky130_fd_sc_hd__o22a_1
X_599_ net35 net41 VGND VGND VPWR VPWR _070_ sky130_fd_sc_hd__nand2_1
X_668_ net43 net34 _188_ net46 VGND VGND VPWR VPWR _139_ sky130_fd_sc_hd__o211a_1
XFILLER_25_49 VGND VGND VPWR VPWR sky130_fd_sc_hd__decap_6
XFILLER_41_15 VPWR VGND VPWR VGND sky130_ef_sc_hd__decap_12
XFILLER_1_225 VPWR VGND VPWR VGND sky130_ef_sc_hd__decap_12
X_522_ _415_ _449_ VGND VGND VPWR VPWR _451_ sky130_fd_sc_hd__xor2_1
XFILLER_17_104 VGND VGND VPWR VPWR sky130_fd_sc_hd__decap_8
XFILLER_40_195 VGND VGND VPWR VPWR sky130_fd_sc_hd__fill_1
XFILLER_15_93 VGND VGND VPWR VPWR sky130_fd_sc_hd__decap_3
XTAP_TAPCELL_ROW_18_176 VGND VPWR sky130_fd_sc_hd__tapvpwrvgnd_1
XFILLER_23_107 VGND VGND VPWR VPWR sky130_fd_sc_hd__fill_1
XFILLER_14_107 VPWR VGND VPWR VGND sky130_ef_sc_hd__decap_12
XFILLER_22_195 VGND VGND VPWR VPWR sky130_fd_sc_hd__fill_1
XTAP_TAPCELL_ROW_9_133 VGND VPWR sky130_fd_sc_hd__tapvpwrvgnd_1
XFILLER_7_3 VPWR VGND VPWR VGND sky130_ef_sc_hd__decap_12
X_505_ _433_ VGND VGND VPWR VPWR _434_ sky130_fd_sc_hd__inv_2
XFILLER_9_111 VGND VGND VPWR VPWR sky130_fd_sc_hd__fill_1
XFILLER_36_221 VPWR VGND VPWR VGND sky130_ef_sc_hd__decap_12
XTAP_TAPCELL_ROW_37_260 VGND VPWR sky130_fd_sc_hd__tapvpwrvgnd_1
XFILLER_10_165 VPWR VGND VPWR VGND sky130_ef_sc_hd__decap_12
XFILLER_10_121 VPWR VGND VPWR VGND sky130_ef_sc_hd__decap_12
XTAP_TAPCELL_ROW_12_149 VGND VPWR sky130_fd_sc_hd__tapvpwrvgnd_1
XTAP_TAPCELL_ROW_20_182 VGND VPWR sky130_fd_sc_hd__tapvpwrvgnd_1
XFILLER_12_83 VGND VGND VPWR VPWR sky130_fd_sc_hd__fill_1
XFILLER_18_221 VGND VGND VPWR VPWR sky130_fd_sc_hd__decap_6
XTAP_TAPCELL_ROW_3_106 VGND VPWR sky130_fd_sc_hd__tapvpwrvgnd_1
XFILLER_17_39 VGND VGND VPWR VPWR sky130_fd_sc_hd__decap_8
XFILLER_33_27 VGND VGND VPWR VPWR sky130_fd_sc_hd__fill_2
X_770_ _243_ _221_ VGND VGND VPWR VPWR net24 sky130_fd_sc_hd__nand2b_1
XFILLER_31_7 VGND VGND VPWR VPWR sky130_fd_sc_hd__fill_1
XFILLER_0_53 VGND VGND VPWR VPWR sky130_fd_sc_hd__decap_3
XFILLER_0_97 VPWR VGND VPWR VGND sky130_ef_sc_hd__decap_12
X_899_ _210_ _220_ _252_ net55 VGND VGND VPWR VPWR _382_ sky130_fd_sc_hd__or4b_1
XFILLER_9_51 VGND VGND VPWR VPWR sky130_fd_sc_hd__decap_4
XFILLER_21_238 VGND VGND VPWR VPWR sky130_fd_sc_hd__decap_6
XTAP_TAPCELL_ROW_31_233 VGND VPWR sky130_fd_sc_hd__tapvpwrvgnd_1
XFILLER_0_109 VGND VGND VPWR VPWR sky130_fd_sc_hd__decap_3
XFILLER_28_27 VGND VGND VPWR VPWR sky130_fd_sc_hd__fill_1
XFILLER_28_49 VGND VGND VPWR VPWR sky130_fd_sc_hd__fill_2
XFILLER_8_209 VPWR VGND VPWR VGND sky130_ef_sc_hd__decap_12
X_822_ _298_ VGND VGND VPWR VPWR _299_ sky130_fd_sc_hd__inv_2
X_684_ _153_ _154_ VGND VGND VPWR VPWR _155_ sky130_fd_sc_hd__or2_1
XFILLER_18_93 VGND VGND VPWR VPWR sky130_fd_sc_hd__decap_8
X_753_ net40 net63 _007_ VGND VGND VPWR VPWR _225_ sky130_fd_sc_hd__and3_1
XFILLER_22_3 VPWR VGND VPWR VGND sky130_ef_sc_hd__decap_12
XFILLER_14_29 VPWR VGND VPWR VGND sky130_ef_sc_hd__decap_12
XFILLER_39_15 VPWR VGND VPWR VGND sky130_ef_sc_hd__decap_12
XFILLER_29_113 VGND VGND VPWR VPWR sky130_fd_sc_hd__decap_6
XFILLER_4_245 VGND VGND VPWR VPWR sky130_fd_sc_hd__decap_6
XFILLER_20_83 VGND VGND VPWR VPWR sky130_fd_sc_hd__fill_1
X_805_ net40 net60 _255_ _254_ VGND VGND VPWR VPWR _280_ sky130_fd_sc_hd__a31oi_2
XFILLER_29_92 VGND VGND VPWR VPWR sky130_fd_sc_hd__decap_4
X_736_ _159_ _206_ VGND VGND VPWR VPWR _207_ sky130_fd_sc_hd__and2b_1
XFILLER_43_182 VGND VGND VPWR VPWR sky130_fd_sc_hd__decap_3
X_667_ net34 _136_ VGND VGND VPWR VPWR _138_ sky130_fd_sc_hd__nor2_1
X_598_ net59 _066_ VGND VGND VPWR VPWR _069_ sky130_fd_sc_hd__and2_1
XFILLER_6_41 VPWR VGND VPWR VGND sky130_ef_sc_hd__decap_12
XFILLER_6_85 VPWR VGND VPWR VGND sky130_ef_sc_hd__decap_12
XFILLER_25_17 VPWR VGND VPWR VGND sky130_ef_sc_hd__decap_12
XFILLER_41_119 VGND VGND VPWR VPWR sky130_fd_sc_hd__fill_2
XFILLER_41_27 VPWR VGND VPWR VGND sky130_ef_sc_hd__decap_12
XFILLER_1_237 VPWR VGND VPWR VGND sky130_ef_sc_hd__decap_12
X_521_ _415_ _449_ VGND VGND VPWR VPWR _450_ sky130_fd_sc_hd__xnor2_1
XFILLER_25_160 VGND VGND VPWR VPWR sky130_fd_sc_hd__fill_1
XFILLER_40_141 VPWR VGND VPWR VGND sky130_ef_sc_hd__decap_12
XFILLER_31_82 VPWR VGND VPWR VGND sky130_ef_sc_hd__decap_12
X_719_ net66 net64 _160_ VGND VGND VPWR VPWR _189_ sky130_fd_sc_hd__o21a_1
XFILLER_16_171 VPWR VGND VPWR VGND sky130_ef_sc_hd__decap_12
XTAP_TAPCELL_ROW_18_177 VGND VPWR sky130_fd_sc_hd__tapvpwrvgnd_1
XFILLER_36_38 VPWR VGND VPWR VGND sky130_ef_sc_hd__decap_12
XFILLER_14_119 VPWR VGND VPWR VGND sky130_ef_sc_hd__decap_12
XFILLER_22_152 VPWR VGND VPWR VGND sky130_ef_sc_hd__decap_12
XTAP_TAPCELL_ROW_9_134 VGND VPWR sky130_fd_sc_hd__tapvpwrvgnd_1
X_504_ _431_ _432_ VGND VGND VPWR VPWR _433_ sky130_fd_sc_hd__nand2_1
XFILLER_9_167 VGND VGND VPWR VPWR sky130_fd_sc_hd__fill_1
XFILLER_36_233 VGND VGND VPWR VPWR sky130_fd_sc_hd__decap_4
XFILLER_22_29 VGND VGND VPWR VPWR sky130_fd_sc_hd__decap_6
XTAP_TAPCELL_ROW_37_261 VGND VPWR sky130_fd_sc_hd__tapvpwrvgnd_1
XFILLER_10_177 VPWR VGND VPWR VGND sky130_ef_sc_hd__decap_12
XFILLER_10_133 VGND VGND VPWR VPWR sky130_fd_sc_hd__decap_6
XTAP_TAPCELL_ROW_20_183 VGND VPWR sky130_fd_sc_hd__tapvpwrvgnd_1
XFILLER_18_244 VGND VGND VPWR VPWR sky130_fd_sc_hd__decap_8
XFILLER_33_225 VGND VGND VPWR VPWR sky130_fd_sc_hd__decap_8
XTAP_TAPCELL_ROW_43_286 VGND VPWR sky130_fd_sc_hd__tapvpwrvgnd_1
XFILLER_33_258 VGND VGND VPWR VPWR sky130_fd_sc_hd__fill_1
XFILLER_5_181 VPWR VGND VPWR VGND sky130_ef_sc_hd__decap_12
XTAP_TAPCELL_ROW_3_107 VGND VPWR sky130_fd_sc_hd__tapvpwrvgnd_1
XTAP_TAPCELL_ROW_26_209 VGND VPWR sky130_fd_sc_hd__tapvpwrvgnd_1
XFILLER_15_203 VGND VGND VPWR VPWR sky130_fd_sc_hd__decap_8
XFILLER_23_94 VGND VGND VPWR VPWR sky130_fd_sc_hd__decap_6
XFILLER_2_195 VGND VGND VPWR VPWR sky130_fd_sc_hd__fill_1
X_898_ net37 net56 net17 net38 VGND VGND VPWR VPWR _380_ sky130_fd_sc_hd__a22o_1
XTAP_TAPCELL_ROW_31_234 VGND VPWR sky130_fd_sc_hd__tapvpwrvgnd_1
X_752_ net38 net63 VGND VGND VPWR VPWR _224_ sky130_fd_sc_hd__nand2_1
X_821_ _261_ _297_ VGND VGND VPWR VPWR _298_ sky130_fd_sc_hd__or2_1
X_683_ net46 net43 net38 net41 VGND VGND VPWR VPWR _154_ sky130_fd_sc_hd__or4_1
XFILLER_18_72 VGND VGND VPWR VPWR sky130_fd_sc_hd__fill_1
XFILLER_34_93 VGND VGND VPWR VPWR sky130_fd_sc_hd__decap_3
XFILLER_15_3 VPWR VGND VPWR VGND sky130_ef_sc_hd__decap_12
XFILLER_30_29 VGND VGND VPWR VPWR sky130_fd_sc_hd__decap_6
XFILLER_39_27 VPWR VGND VPWR VGND sky130_ef_sc_hd__decap_12
XFILLER_29_169 VPWR VGND VPWR VGND sky130_ef_sc_hd__decap_12
X_804_ _277_ _278_ VGND VGND VPWR VPWR _279_ sky130_fd_sc_hd__nor2_1
X_735_ net40 net60 VGND VGND VPWR VPWR _206_ sky130_fd_sc_hd__nand2_1
XFILLER_43_161 VGND VGND VPWR VPWR sky130_fd_sc_hd__decap_3
X_597_ net59 _066_ VGND VGND VPWR VPWR _068_ sky130_fd_sc_hd__nor2_1
X_666_ _188_ net46 VGND VGND VPWR VPWR _137_ sky130_fd_sc_hd__and2_1
XFILLER_6_53 VPWR VGND VPWR VGND sky130_ef_sc_hd__decap_12
XFILLER_6_97 VPWR VGND VPWR VGND sky130_ef_sc_hd__decap_12
XFILLER_25_29 VGND VGND VPWR VPWR sky130_fd_sc_hd__decap_6
XFILLER_41_39 VPWR VGND VPWR VGND sky130_ef_sc_hd__decap_12
XFILLER_1_205 VPWR VGND VPWR VGND sky130_ef_sc_hd__decap_12
XFILLER_1_249 VGND VGND VPWR VPWR sky130_fd_sc_hd__decap_8
X_520_ net34 _433_ VGND VGND VPWR VPWR _449_ sky130_fd_sc_hd__xnor2_1
XFILLER_40_153 VGND VGND VPWR VPWR sky130_fd_sc_hd__decap_4
XFILLER_15_51 VGND VGND VPWR VPWR sky130_fd_sc_hd__decap_4
XFILLER_17_128 VGND VGND VPWR VPWR sky130_fd_sc_hd__decap_3
XFILLER_31_94 VPWR VGND VPWR VGND sky130_ef_sc_hd__decap_12
X_718_ _180_ _187_ VGND VGND VPWR VPWR net22 sky130_fd_sc_hd__or2_1
X_649_ _075_ _076_ VGND VGND VPWR VPWR _120_ sky130_fd_sc_hd__or2_1
XFILLER_16_183 VPWR VGND VPWR VGND sky130_ef_sc_hd__decap_12
XFILLER_31_164 VGND VGND VPWR VPWR sky130_fd_sc_hd__decap_4
XFILLER_22_164 VGND VGND VPWR VPWR sky130_fd_sc_hd__decap_4
XTAP_TAPCELL_ROW_9_135 VGND VPWR sky130_fd_sc_hd__tapvpwrvgnd_1
X_503_ _408_ _416_ _417_ _422_ VGND VGND VPWR VPWR _432_ sky130_fd_sc_hd__or4_1
XFILLER_9_113 VPWR VGND VPWR VGND sky130_ef_sc_hd__decap_12
XTAP_TAPCELL_ROW_37_262 VGND VPWR sky130_fd_sc_hd__tapvpwrvgnd_1
XFILLER_10_189 VGND VGND VPWR VPWR sky130_fd_sc_hd__decap_6
XFILLER_12_41 VPWR VGND VPWR VGND sky130_ef_sc_hd__decap_12
XFILLER_12_85 VPWR VGND VPWR VGND sky130_ef_sc_hd__decap_12
XTAP_TAPCELL_ROW_20_184 VGND VPWR sky130_fd_sc_hd__tapvpwrvgnd_1
XFILLER_18_201 VPWR VGND VPWR VGND sky130_ef_sc_hd__decap_12
XPHY_EDGE_ROW_25_Left_69 VGND VGND VPWR VPWR sky130_fd_sc_hd__decap_3
XPHY_EDGE_ROW_16_Right_16 VGND VGND VPWR VPWR sky130_fd_sc_hd__decap_3
XFILLER_18_234 VGND VGND VPWR VPWR sky130_fd_sc_hd__decap_3
XTAP_TAPCELL_ROW_43_287 VGND VPWR sky130_fd_sc_hd__tapvpwrvgnd_1
XPHY_EDGE_ROW_25_Right_25 VGND VGND VPWR VPWR sky130_fd_sc_hd__decap_3
XFILLER_5_193 VPWR VGND VPWR VGND sky130_ef_sc_hd__decap_12
XTAP_TAPCELL_ROW_3_108 VGND VPWR sky130_fd_sc_hd__tapvpwrvgnd_1
XPHY_EDGE_ROW_34_Right_34 VGND VGND VPWR VPWR sky130_fd_sc_hd__decap_3
XFILLER_24_237 VGND VGND VPWR VPWR sky130_fd_sc_hd__decap_3
XPHY_EDGE_ROW_43_Right_43 VGND VGND VPWR VPWR sky130_fd_sc_hd__decap_3
XFILLER_2_141 VPWR VGND VPWR VGND sky130_ef_sc_hd__decap_12
X_897_ net46 net42 net49 net51 VGND VGND VPWR VPWR _379_ sky130_fd_sc_hd__nand4_1
XTAP_TAPCELL_ROW_31_235 VGND VPWR sky130_fd_sc_hd__tapvpwrvgnd_1
XFILLER_28_29 VPWR VGND VPWR VGND sky130_ef_sc_hd__decap_12
XFILLER_20_251 VGND VGND VPWR VPWR sky130_fd_sc_hd__fill_1
X_682_ net69 net37 net12 net67 VGND VGND VPWR VPWR _153_ sky130_fd_sc_hd__or4_1
X_751_ net42 net60 VGND VGND VPWR VPWR _223_ sky130_fd_sc_hd__nand2_1
X_820_ _249_ _296_ VGND VGND VPWR VPWR _297_ sky130_fd_sc_hd__xnor2_1
XFILLER_34_83 VGND VGND VPWR VPWR sky130_fd_sc_hd__fill_1
XFILLER_38_137 VGND VGND VPWR VPWR sky130_fd_sc_hd__decap_3
XPHY_EDGE_ROW_28_Left_72 VGND VGND VPWR VPWR sky130_fd_sc_hd__decap_3
XPHY_EDGE_ROW_12_Left_56 VGND VGND VPWR VPWR sky130_fd_sc_hd__decap_3
XFILLER_39_39 VPWR VGND VPWR VGND sky130_ef_sc_hd__decap_12
XPHY_EDGE_ROW_2_Right_2 VGND VGND VPWR VPWR sky130_fd_sc_hd__decap_3
XFILLER_20_41 VPWR VGND VPWR VGND sky130_ef_sc_hd__decap_12
X_734_ _203_ _204_ VGND VGND VPWR VPWR _205_ sky130_fd_sc_hd__nor2_1
X_803_ _274_ _275_ _276_ VGND VGND VPWR VPWR _278_ sky130_fd_sc_hd__nor3_1
X_665_ net43 _135_ net29 VGND VGND VPWR VPWR _136_ sky130_fd_sc_hd__mux2_1
X_596_ _066_ VGND VGND VPWR VPWR _067_ sky130_fd_sc_hd__inv_2
XFILLER_6_65 VPWR VGND VPWR VGND sky130_ef_sc_hd__decap_12
XFILLER_34_151 VGND VGND VPWR VPWR sky130_fd_sc_hd__fill_1
XFILLER_1_217 VGND VGND VPWR VPWR sky130_fd_sc_hd__decap_6
X_717_ _295_ net29 _185_ _186_ VGND VGND VPWR VPWR _187_ sky130_fd_sc_hd__a22o_1
X_648_ _113_ _114_ _117_ _118_ VGND VGND VPWR VPWR _119_ sky130_fd_sc_hd__nand4b_1
XFILLER_16_195 VGND VGND VPWR VPWR sky130_fd_sc_hd__fill_1
X_579_ _015_ net31 _002_ VGND VGND VPWR VPWR _050_ sky130_fd_sc_hd__a21o_1
XFILLER_31_143 VGND VGND VPWR VPWR sky130_fd_sc_hd__decap_6
XFILLER_31_176 VPWR VGND VPWR VGND sky130_ef_sc_hd__decap_12
XFILLER_39_232 VPWR VGND VPWR VGND sky130_ef_sc_hd__decap_12
XTAP_TAPCELL_ROW_9_136 VGND VPWR sky130_fd_sc_hd__tapvpwrvgnd_1
X_502_ _408_ _422_ net69 VGND VGND VPWR VPWR _431_ sky130_fd_sc_hd__o21ai_1
XFILLER_42_83 VGND VGND VPWR VPWR sky130_fd_sc_hd__fill_1
XFILLER_9_169 VPWR VGND VPWR VGND sky130_ef_sc_hd__decap_12
XFILLER_9_125 VPWR VGND VPWR VGND sky130_ef_sc_hd__decap_12
XFILLER_3_55 VGND VGND VPWR VPWR sky130_fd_sc_hd__fill_1
XFILLER_42_216 VPWR VGND VPWR VGND sky130_ef_sc_hd__decap_12
XFILLER_27_235 VPWR VGND VPWR VGND sky130_ef_sc_hd__decap_12
XFILLER_6_139 VGND VGND VPWR VPWR sky130_fd_sc_hd__fill_1
XFILLER_5_3 VPWR VGND VPWR VGND sky130_ef_sc_hd__decap_12
XPHY_EDGE_ROW_0_Left_44 VGND VGND VPWR VPWR sky130_fd_sc_hd__decap_3
XFILLER_12_53 VPWR VGND VPWR VGND sky130_ef_sc_hd__decap_12
XFILLER_12_97 VPWR VGND VPWR VGND sky130_ef_sc_hd__decap_12
XTAP_TAPCELL_ROW_20_185 VGND VPWR sky130_fd_sc_hd__tapvpwrvgnd_1
XFILLER_18_213 VGND VGND VPWR VPWR sky130_fd_sc_hd__fill_1
XFILLER_37_61 VGND VGND VPWR VPWR sky130_fd_sc_hd__decap_8
XFILLER_33_205 VGND VGND VPWR VPWR sky130_fd_sc_hd__fill_2
XTAP_TAPCELL_ROW_43_288 VGND VPWR sky130_fd_sc_hd__tapvpwrvgnd_1
XFILLER_38_3 VPWR VGND VPWR VGND sky130_ef_sc_hd__decap_12
XFILLER_5_161 VGND VGND VPWR VPWR sky130_fd_sc_hd__decap_6
XTAP_TAPCELL_ROW_3_109 VGND VPWR sky130_fd_sc_hd__tapvpwrvgnd_1
XFILLER_24_205 VGND VGND VPWR VPWR sky130_fd_sc_hd__fill_1
XPHY_EDGE_ROW_42_Left_86 VGND VGND VPWR VPWR sky130_fd_sc_hd__decap_3
XFILLER_2_197 VPWR VGND VPWR VGND sky130_ef_sc_hd__decap_12
XFILLER_2_153 VPWR VGND VPWR VGND sky130_ef_sc_hd__decap_12
X_896_ net46 net49 net51 net43 VGND VGND VPWR VPWR _378_ sky130_fd_sc_hd__a22o_1
XFILLER_21_208 VGND VGND VPWR VPWR sky130_fd_sc_hd__fill_2
X_750_ _198_ _201_ VGND VGND VPWR VPWR _222_ sky130_fd_sc_hd__nor2_1
XFILLER_18_41 VGND VGND VPWR VPWR sky130_fd_sc_hd__decap_8
X_681_ _306_ _151_ VGND VGND VPWR VPWR _152_ sky130_fd_sc_hd__or2_1
XFILLER_34_51 VPWR VGND VPWR VGND sky130_ef_sc_hd__decap_12
XFILLER_7_223 VGND VGND VPWR VPWR sky130_fd_sc_hd__fill_1
XFILLER_38_105 VGND VGND VPWR VPWR sky130_fd_sc_hd__fill_1
X_879_ _303_ _358_ VGND VGND VPWR VPWR _361_ sky130_fd_sc_hd__nand2_1
XFILLER_20_53 VGND VGND VPWR VPWR sky130_fd_sc_hd__decap_3
X_802_ _275_ _276_ _274_ VGND VGND VPWR VPWR _277_ sky130_fd_sc_hd__o21a_1
XFILLER_29_51 VGND VGND VPWR VPWR sky130_fd_sc_hd__decap_4
XFILLER_43_141 VGND VGND VPWR VPWR sky130_fd_sc_hd__fill_2
X_733_ _176_ _202_ VGND VGND VPWR VPWR _204_ sky130_fd_sc_hd__nor2_1
X_595_ _023_ _065_ net30 VGND VGND VPWR VPWR _066_ sky130_fd_sc_hd__mux2_1
X_664_ _076_ _134_ VGND VGND VPWR VPWR _135_ sky130_fd_sc_hd__nand2_1
XFILLER_6_77 VGND VGND VPWR VPWR sky130_fd_sc_hd__decap_6
XFILLER_20_3 VPWR VGND VPWR VGND sky130_ef_sc_hd__decap_12
XFILLER_34_185 VGND VGND VPWR VPWR sky130_fd_sc_hd__decap_4
XFILLER_31_63 VGND VGND VPWR VPWR sky130_fd_sc_hd__decap_4
X_716_ _147_ _184_ _161_ VGND VGND VPWR VPWR _186_ sky130_fd_sc_hd__a21oi_1
XFILLER_16_141 VPWR VGND VPWR VGND sky130_ef_sc_hd__decap_12
X_578_ _005_ _008_ VGND VGND VPWR VPWR _049_ sky130_fd_sc_hd__xnor2_1
X_647_ net55 _116_ VGND VGND VPWR VPWR _118_ sky130_fd_sc_hd__nand2_1
XFILLER_31_188 VGND VGND VPWR VPWR sky130_fd_sc_hd__fill_2
.ends
